* Layout netlist hierachical

Xbandgap_cm_0 w_41706_23485# m3_53511_9912# m2_50770_8396# m2_49918_7454# m3_64941_21277#
+ m2_36786_6525# w_9284_9257# m2_50202_7790# m2_36502_6193# VAPWR m3_58309_21277#
+ m2_37354_7139# m2_37070_6795# m2_50486_8120# VGND bandgap_cm
Xtestbuffer_0 m3_60905_21401# m3_65487_22109# w_55284_25430# bias VAPWR VGND testbuffer
Xlevelshifter_0[0] en VDPWR VAPWR m3_53511_9912# VDPWR VAPWR VGND VGND levelshifter
Xlevelshifter_0[1] trim[0] VDPWR VAPWR m2_50770_8396# VDPWR VAPWR VGND VGND levelshifter
Xlevelshifter_0[2] trim[1] VDPWR VAPWR m2_50486_8120# VDPWR VAPWR VGND VGND levelshifter
Xlevelshifter_0[3] trim[2] VDPWR VAPWR m2_50202_7790# VDPWR VAPWR VGND VGND levelshifter
Xlevelshifter_0[4] trim[3] VDPWR VAPWR m2_49918_7454# VDPWR VAPWR VGND VGND levelshifter
Xlevelshifter_0[5] trim[4] VDPWR VAPWR m2_37354_7139# VDPWR VAPWR VGND VGND levelshifter
Xlevelshifter_0[6] trim[5] VDPWR VAPWR m2_37070_6795# VDPWR VAPWR VGND VGND levelshifter
Xlevelshifter_0[7] trim[6] VDPWR VAPWR m2_36786_6525# VDPWR VAPWR VGND VGND levelshifter
Xlevelshifter_0[8] trim[7] VDPWR VAPWR m2_36502_6193# VDPWR VAPWR VGND VGND levelshifter
Xlevelshifter_0[9] dsw[0] VDPWR VAPWR m3_62910_8048# VDPWR VAPWR VGND VGND levelshifter
Xlevelshifter_0[10] dsw[1] VDPWR VAPWR m3_63806_8346# VDPWR VAPWR VGND VGND levelshifter
Xspdt__group_0 m3_60905_21401# vout w_55284_17504# m3_64941_21277# vext m3_62910_8048#
+ m3_63806_8346# m3_65487_22109# VAPWR VGND m3_58309_21277# spdt__group
*.ends

.subckt nfet_06v0_8u_8u_1nf a_192_272# a_280_180# a_1880_272# a_48_48#
X0 a_1880_272# a_280_180# a_192_272# a_48_48# nfet_06v0 ad=3.52p pd=16.88u as=3.52p ps=16.88u w=8u l=8u
.ends

.subckt bg__mb2_mb3 m2_61_3679# m2_61_4900# m2_61_2331# m2_61_5655# m2_61_4307# m2_61_2924#
+ VSUBS
Xnfet_06v0_8u_8u_1nf_0[0|0] VSUBS VSUBS VSUBS VSUBS nfet_06v0_8u_8u_1nf
Xnfet_06v0_8u_8u_1nf_0[1|0] VSUBS VSUBS VSUBS VSUBS nfet_06v0_8u_8u_1nf
Xnfet_06v0_8u_8u_1nf_0[2|0] VSUBS VSUBS VSUBS VSUBS nfet_06v0_8u_8u_1nf
Xnfet_06v0_8u_8u_1nf_0[3|0] VSUBS VSUBS VSUBS VSUBS nfet_06v0_8u_8u_1nf
Xnfet_06v0_8u_8u_1nf_0[0|1] VSUBS VSUBS VSUBS VSUBS nfet_06v0_8u_8u_1nf
Xnfet_06v0_8u_8u_1nf_0[1|1] m2_61_2924# m2_61_3679# m2_61_3679# VSUBS nfet_06v0_8u_8u_1nf
Xnfet_06v0_8u_8u_1nf_0[2|1] m2_61_4900# m2_61_5655# m2_61_5655# VSUBS nfet_06v0_8u_8u_1nf
Xnfet_06v0_8u_8u_1nf_0[3|1] VSUBS VSUBS VSUBS VSUBS nfet_06v0_8u_8u_1nf
Xnfet_06v0_8u_8u_1nf_0[0|2] VSUBS VSUBS VSUBS VSUBS nfet_06v0_8u_8u_1nf
Xnfet_06v0_8u_8u_1nf_0[1|2] m2_61_2924# m2_61_3679# m2_61_2331# VSUBS nfet_06v0_8u_8u_1nf
Xnfet_06v0_8u_8u_1nf_0[2|2] m2_61_4307# m2_61_5655# m2_61_4900# VSUBS nfet_06v0_8u_8u_1nf
Xnfet_06v0_8u_8u_1nf_0[3|2] VSUBS VSUBS VSUBS VSUBS nfet_06v0_8u_8u_1nf
Xnfet_06v0_8u_8u_1nf_0[0|3] VSUBS VSUBS VSUBS VSUBS nfet_06v0_8u_8u_1nf
Xnfet_06v0_8u_8u_1nf_0[1|3] m2_61_3679# m2_61_3679# m2_61_2924# VSUBS nfet_06v0_8u_8u_1nf
Xnfet_06v0_8u_8u_1nf_0[2|3] m2_61_5655# m2_61_5655# m2_61_4900# VSUBS nfet_06v0_8u_8u_1nf
Xnfet_06v0_8u_8u_1nf_0[3|3] VSUBS VSUBS VSUBS VSUBS nfet_06v0_8u_8u_1nf
Xnfet_06v0_8u_8u_1nf_0[0|4] VSUBS VSUBS VSUBS VSUBS nfet_06v0_8u_8u_1nf
Xnfet_06v0_8u_8u_1nf_0[1|4] VSUBS VSUBS VSUBS VSUBS nfet_06v0_8u_8u_1nf
Xnfet_06v0_8u_8u_1nf_0[2|4] VSUBS VSUBS VSUBS VSUBS nfet_06v0_8u_8u_1nf
Xnfet_06v0_8u_8u_1nf_0[3|4] VSUBS VSUBS VSUBS VSUBS nfet_06v0_8u_8u_1nf
.ends

.subckt nfet_06v0_2u_1u_1nf a_480_272# a_192_272# a_280_180# a_48_48#
X0 a_480_272# a_280_180# a_192_272# a_48_48# nfet_06v0 ad=0.88p pd=4.88u as=0.88p ps=4.88u w=2u l=1u
.ends

.subckt pfet_06v0_2u_1u_1nf a_480_272# a_192_272# a_280_180# w_16_16#
X0 a_480_272# a_280_180# a_192_272# w_16_16# pfet_06v0 ad=0.88p pd=4.88u as=0.88p ps=4.88u w=2u l=1u
.ends

.subckt bg__mi1_mi2_me1_me2_me3_me4 m2_294_694# via__M1_M2_SQU_0/m1_0_0# via__M1_M2_SQU_1/m1_0_0#
+ via__M1_M2_SQU_2/m1_0_0# via__M1_M2_SQU_3/m1_0_0# VSUBS m1_61_1458#
Xnfet_06v0_2u_1u_1nf_0[0] m2_498_378# VSUBS m2_294_694# VSUBS nfet_06v0_2u_1u_1nf
Xnfet_06v0_2u_1u_1nf_0[1] via__M1_M2_SQU_2/m1_0_0# VSUBS m2_498_378# VSUBS nfet_06v0_2u_1u_1nf
Xnfet_06v0_2u_1u_1nf_0[2] via__M1_M2_SQU_3/m1_0_0# VSUBS m2_498_378# VSUBS nfet_06v0_2u_1u_1nf
Xpfet_06v0_2u_1u_1nf_0[0] m2_498_378# m1_61_1458# m2_294_694# m1_61_1458# pfet_06v0_2u_1u_1nf
Xpfet_06v0_2u_1u_1nf_0[1] via__M1_M2_SQU_0/m1_0_0# m1_61_1458# m2_294_694# m1_61_1458#
+ pfet_06v0_2u_1u_1nf
Xpfet_06v0_2u_1u_1nf_0[2] via__M1_M2_SQU_1/m1_0_0# m1_61_1458# m2_294_694# m1_61_1458#
+ pfet_06v0_2u_1u_1nf
.ends

.subckt nfet_06v0_1u_1u_1nf a_480_272# a_192_272# a_280_180# a_48_48#
X0 a_480_272# a_280_180# a_192_272# a_48_48# nfet_06v0 ad=0.44p pd=2.88u as=0.44p ps=2.88u w=1u l=1u
.ends

.subckt cap_mim_10u_10u m4_120_120# m4_0_0#
X0 m4_120_120# m4_0_0# cap_mim_2f0_m4m5_noshield c_width=10u c_length=10u
.ends

.subckt bg__ms1_ms2_ms3_ms4_c1 m2_61_286# m2_935_505# m2_2274_286# m2_294_505# via__M1_M2_MIN_0/m1_0_0#
+ VSUBS
Xnfet_06v0_1u_1u_1nf_0[0] VSUBS m2_61_286# m2_294_505# VSUBS nfet_06v0_1u_1u_1nf
Xnfet_06v0_1u_1u_1nf_0[1] m2_1090_286# m2_294_505# m2_935_505# VSUBS nfet_06v0_1u_1u_1nf
Xnfet_06v0_1u_1u_1nf_0[2] VSUBS m2_1090_286# via__M1_M2_MIN_0/m1_0_0# VSUBS nfet_06v0_1u_1u_1nf
Xnfet_06v0_1u_1u_1nf_0[3] m2_2274_286# m2_1090_286# m2_935_505# VSUBS nfet_06v0_1u_1u_1nf
Xcap_mim_10u_10u_0 m2_2274_286# VSUBS cap_mim_10u_10u
.ends

.subckt ppoly_u_1k_6p0_1u_20u w_8_8# a_244_244# a_244_4366#
X0 a_244_4366# a_244_244# w_8_8# ppolyf_u_1k_6p0 r_width=1u r_length=20u
.ends

.subckt bg__r1_r2_r3_ro m2_9068_4406# m2_7412_4406# m3_14588_n259# m2_1892_n259# m3_22868_n259#
+ m3_9620_n259# m2_27284_n259# m2_28388_4406# w_n24_n40#
Xppoly_u_1k_6p0_1u_20u_0[0] w_n24_n40# w_n24_n40# w_n24_n40# ppoly_u_1k_6p0_1u_20u
Xppoly_u_1k_6p0_1u_20u_0[1] w_n24_n40# w_n24_n40# w_n24_n40# ppoly_u_1k_6p0_1u_20u
Xppoly_u_1k_6p0_1u_20u_0[2] w_n24_n40# w_n24_n40# w_n24_n40# ppoly_u_1k_6p0_1u_20u
Xppoly_u_1k_6p0_1u_20u_0[3] w_n24_n40# m2_1892_n259# m2_1892_4406# ppoly_u_1k_6p0_1u_20u
Xppoly_u_1k_6p0_1u_20u_0[4] w_n24_n40# m2_2444_234# m2_1892_4406# ppoly_u_1k_6p0_1u_20u
Xppoly_u_1k_6p0_1u_20u_0[5] w_n24_n40# m2_2444_234# m2_2996_4406# ppoly_u_1k_6p0_1u_20u
Xppoly_u_1k_6p0_1u_20u_0[6] w_n24_n40# m2_3548_234# m2_2996_4406# ppoly_u_1k_6p0_1u_20u
Xppoly_u_1k_6p0_1u_20u_0[7] w_n24_n40# m2_3548_234# m2_4100_4406# ppoly_u_1k_6p0_1u_20u
Xppoly_u_1k_6p0_1u_20u_0[8] w_n24_n40# m2_4652_234# m2_4100_4406# ppoly_u_1k_6p0_1u_20u
Xppoly_u_1k_6p0_1u_20u_0[9] w_n24_n40# m2_4652_234# m2_5204_4406# ppoly_u_1k_6p0_1u_20u
Xppoly_u_1k_6p0_1u_20u_0[10] w_n24_n40# m2_5756_234# m2_5204_4406# ppoly_u_1k_6p0_1u_20u
Xppoly_u_1k_6p0_1u_20u_0[11] w_n24_n40# m2_5756_234# m2_6308_4406# ppoly_u_1k_6p0_1u_20u
Xppoly_u_1k_6p0_1u_20u_0[12] w_n24_n40# m2_6860_234# m2_6308_4406# ppoly_u_1k_6p0_1u_20u
Xppoly_u_1k_6p0_1u_20u_0[13] w_n24_n40# m2_6860_234# m2_7412_4406# ppoly_u_1k_6p0_1u_20u
Xppoly_u_1k_6p0_1u_20u_0[14] w_n24_n40# w_n24_n40# w_n24_n40# ppoly_u_1k_6p0_1u_20u
Xppoly_u_1k_6p0_1u_20u_0[15] w_n24_n40# w_n24_n40# w_n24_n40# ppoly_u_1k_6p0_1u_20u
Xppoly_u_1k_6p0_1u_20u_0[16] w_n24_n40# m2_9068_n166# m2_9068_4406# ppoly_u_1k_6p0_1u_20u
Xppoly_u_1k_6p0_1u_20u_0[17] w_n24_n40# m3_9620_n259# m2_9620_4406# ppoly_u_1k_6p0_1u_20u
Xppoly_u_1k_6p0_1u_20u_0[18] w_n24_n40# m2_9068_n166# m2_10172_4406# ppoly_u_1k_6p0_1u_20u
Xppoly_u_1k_6p0_1u_20u_0[19] w_n24_n40# m2_10724_n166# m2_10172_4406# ppoly_u_1k_6p0_1u_20u
Xppoly_u_1k_6p0_1u_20u_0[20] w_n24_n40# m2_11276_234# m2_9620_4406# ppoly_u_1k_6p0_1u_20u
Xppoly_u_1k_6p0_1u_20u_0[21] w_n24_n40# m2_11276_234# m2_11828_4406# ppoly_u_1k_6p0_1u_20u
Xppoly_u_1k_6p0_1u_20u_0[22] w_n24_n40# m2_10724_n166# m2_12380_4406# ppoly_u_1k_6p0_1u_20u
Xppoly_u_1k_6p0_1u_20u_0[23] w_n24_n40# m2_12932_n166# m2_12380_4406# ppoly_u_1k_6p0_1u_20u
Xppoly_u_1k_6p0_1u_20u_0[24] w_n24_n40# m2_13484_234# m2_11828_4406# ppoly_u_1k_6p0_1u_20u
Xppoly_u_1k_6p0_1u_20u_0[25] w_n24_n40# m2_13484_234# m2_14036_4406# ppoly_u_1k_6p0_1u_20u
Xppoly_u_1k_6p0_1u_20u_0[26] w_n24_n40# m3_14588_n259# m2_14588_3806# ppoly_u_1k_6p0_1u_20u
Xppoly_u_1k_6p0_1u_20u_0[27] w_n24_n40# m2_12932_n166# m2_15140_4406# ppoly_u_1k_6p0_1u_20u
Xppoly_u_1k_6p0_1u_20u_0[28] w_n24_n40# m2_15692_n166# m2_15140_4406# ppoly_u_1k_6p0_1u_20u
Xppoly_u_1k_6p0_1u_20u_0[29] w_n24_n40# m2_16244_234# m2_14036_4406# ppoly_u_1k_6p0_1u_20u
Xppoly_u_1k_6p0_1u_20u_0[30] w_n24_n40# m2_16244_234# m2_16796_4406# ppoly_u_1k_6p0_1u_20u
Xppoly_u_1k_6p0_1u_20u_0[31] w_n24_n40# m2_15692_n166# m2_17348_4406# ppoly_u_1k_6p0_1u_20u
Xppoly_u_1k_6p0_1u_20u_0[32] w_n24_n40# m2_17900_n166# m2_17348_4406# ppoly_u_1k_6p0_1u_20u
Xppoly_u_1k_6p0_1u_20u_0[33] w_n24_n40# m2_18452_234# m2_16796_4406# ppoly_u_1k_6p0_1u_20u
Xppoly_u_1k_6p0_1u_20u_0[34] w_n24_n40# m2_18452_234# m2_19004_4406# ppoly_u_1k_6p0_1u_20u
Xppoly_u_1k_6p0_1u_20u_0[35] w_n24_n40# m2_17900_n166# m2_19556_4406# ppoly_u_1k_6p0_1u_20u
Xppoly_u_1k_6p0_1u_20u_0[36] w_n24_n40# m2_20108_n166# m2_19556_4406# ppoly_u_1k_6p0_1u_20u
Xppoly_u_1k_6p0_1u_20u_0[37] w_n24_n40# m2_20660_234# m2_19004_4406# ppoly_u_1k_6p0_1u_20u
Xppoly_u_1k_6p0_1u_20u_0[38] w_n24_n40# m2_20660_234# m2_21212_4406# ppoly_u_1k_6p0_1u_20u
Xppoly_u_1k_6p0_1u_20u_0[39] w_n24_n40# m2_20108_n166# m2_21764_4406# ppoly_u_1k_6p0_1u_20u
Xppoly_u_1k_6p0_1u_20u_0[40] w_n24_n40# m2_22316_n166# m2_21764_4406# ppoly_u_1k_6p0_1u_20u
Xppoly_u_1k_6p0_1u_20u_0[41] w_n24_n40# m3_22868_n259# m2_14588_3806# ppoly_u_1k_6p0_1u_20u
Xppoly_u_1k_6p0_1u_20u_0[42] w_n24_n40# m2_23420_234# m2_21212_4406# ppoly_u_1k_6p0_1u_20u
Xppoly_u_1k_6p0_1u_20u_0[43] w_n24_n40# m2_23420_234# m2_23972_4406# ppoly_u_1k_6p0_1u_20u
Xppoly_u_1k_6p0_1u_20u_0[44] w_n24_n40# m2_22316_n166# m2_24524_4406# ppoly_u_1k_6p0_1u_20u
Xppoly_u_1k_6p0_1u_20u_0[45] w_n24_n40# m2_25076_n166# m2_24524_4406# ppoly_u_1k_6p0_1u_20u
Xppoly_u_1k_6p0_1u_20u_0[46] w_n24_n40# m2_25628_234# m2_23972_4406# ppoly_u_1k_6p0_1u_20u
Xppoly_u_1k_6p0_1u_20u_0[47] w_n24_n40# m2_25628_234# m2_26180_4406# ppoly_u_1k_6p0_1u_20u
Xppoly_u_1k_6p0_1u_20u_0[48] w_n24_n40# m2_25076_n166# m2_26732_4406# ppoly_u_1k_6p0_1u_20u
Xppoly_u_1k_6p0_1u_20u_0[49] w_n24_n40# m2_27284_n259# m2_26732_4406# ppoly_u_1k_6p0_1u_20u
Xppoly_u_1k_6p0_1u_20u_0[50] w_n24_n40# m2_27836_234# m2_26180_4406# ppoly_u_1k_6p0_1u_20u
Xppoly_u_1k_6p0_1u_20u_0[51] w_n24_n40# m2_27836_234# m2_28388_4406# ppoly_u_1k_6p0_1u_20u
Xppoly_u_1k_6p0_1u_20u_0[52] w_n24_n40# w_n24_n40# w_n24_n40# ppoly_u_1k_6p0_1u_20u
Xppoly_u_1k_6p0_1u_20u_0[53] w_n24_n40# w_n24_n40# w_n24_n40# ppoly_u_1k_6p0_1u_20u
Xppoly_u_1k_6p0_1u_20u_0[54] w_n24_n40# w_n24_n40# w_n24_n40# ppoly_u_1k_6p0_1u_20u
.ends

.subckt pfet_06v0_8u_8u_1nf a_192_272# a_280_180# w_16_16# a_1880_272#
X0 a_1880_272# a_280_180# a_192_272# w_16_16# pfet_06v0 ad=3.52p pd=16.88u as=3.52p ps=16.88u w=8u l=8u
.ends

.subckt bg__m1_m2_mb1_mo1_mo2 m2_61_2278# m2_61_5822# m2_61_4498# m2_61_2522# m2_61_3254#
+ m2_61_4742# m2_61_5474# m2_61_4254# m2_61_3010# m2_61_5230# m2_61_3846# m2_61_2766#
+ m2_61_3498# m2_61_4986# m1_107_107#
Xpfet_06v0_8u_8u_1nf_0[0|0] m1_107_107# m1_107_107# m1_107_107# m1_107_107# pfet_06v0_8u_8u_1nf
Xpfet_06v0_8u_8u_1nf_0[1|0] m1_107_107# m1_107_107# m1_107_107# m1_107_107# pfet_06v0_8u_8u_1nf
Xpfet_06v0_8u_8u_1nf_0[2|0] m1_107_107# m1_107_107# m1_107_107# m1_107_107# pfet_06v0_8u_8u_1nf
Xpfet_06v0_8u_8u_1nf_0[3|0] m1_107_107# m1_107_107# m1_107_107# m1_107_107# pfet_06v0_8u_8u_1nf
Xpfet_06v0_8u_8u_1nf_0[0|1] m1_107_107# m1_107_107# m1_107_107# m1_107_107# pfet_06v0_8u_8u_1nf
Xpfet_06v0_8u_8u_1nf_0[1|1] m2_61_3498# m2_61_3846# m1_107_107# m2_61_2278# pfet_06v0_8u_8u_1nf
Xpfet_06v0_8u_8u_1nf_0[2|1] m2_61_5474# m2_61_5822# m1_107_107# m2_61_4254# pfet_06v0_8u_8u_1nf
Xpfet_06v0_8u_8u_1nf_0[3|1] m1_107_107# m1_107_107# m1_107_107# m1_107_107# pfet_06v0_8u_8u_1nf
Xpfet_06v0_8u_8u_1nf_0[0|2] m1_107_107# m1_107_107# m1_107_107# m1_107_107# pfet_06v0_8u_8u_1nf
Xpfet_06v0_8u_8u_1nf_0[1|2] m2_61_2766# m2_61_3846# m1_107_107# m2_61_3498# pfet_06v0_8u_8u_1nf
Xpfet_06v0_8u_8u_1nf_0[2|2] m2_61_5230# m2_61_5822# m1_107_107# m2_61_5474# pfet_06v0_8u_8u_1nf
Xpfet_06v0_8u_8u_1nf_0[3|2] m1_107_107# m1_107_107# m1_107_107# m1_107_107# pfet_06v0_8u_8u_1nf
Xpfet_06v0_8u_8u_1nf_0[0|3] m1_107_107# m1_107_107# m1_107_107# m1_107_107# pfet_06v0_8u_8u_1nf
Xpfet_06v0_8u_8u_1nf_0[1|3] m2_61_3498# m2_61_3846# m1_107_107# m2_61_2522# pfet_06v0_8u_8u_1nf
Xpfet_06v0_8u_8u_1nf_0[2|3] m2_61_5474# m2_61_5822# m1_107_107# m2_61_4498# pfet_06v0_8u_8u_1nf
Xpfet_06v0_8u_8u_1nf_0[3|3] m1_107_107# m1_107_107# m1_107_107# m1_107_107# pfet_06v0_8u_8u_1nf
Xpfet_06v0_8u_8u_1nf_0[0|4] m1_107_107# m1_107_107# m1_107_107# m1_107_107# pfet_06v0_8u_8u_1nf
Xpfet_06v0_8u_8u_1nf_0[1|4] m2_61_3010# m2_61_3846# m1_107_107# m2_61_3498# pfet_06v0_8u_8u_1nf
Xpfet_06v0_8u_8u_1nf_0[2|4] m2_61_4986# m2_61_5822# m1_107_107# m2_61_5474# pfet_06v0_8u_8u_1nf
Xpfet_06v0_8u_8u_1nf_0[3|4] m1_107_107# m1_107_107# m1_107_107# m1_107_107# pfet_06v0_8u_8u_1nf
Xpfet_06v0_8u_8u_1nf_0[0|5] m1_107_107# m1_107_107# m1_107_107# m1_107_107# pfet_06v0_8u_8u_1nf
Xpfet_06v0_8u_8u_1nf_0[1|5] m2_61_3498# m2_61_3846# m1_107_107# m2_61_3254# pfet_06v0_8u_8u_1nf
Xpfet_06v0_8u_8u_1nf_0[2|5] m2_61_5474# m2_61_5822# m1_107_107# m2_61_5230# pfet_06v0_8u_8u_1nf
Xpfet_06v0_8u_8u_1nf_0[3|5] m1_107_107# m1_107_107# m1_107_107# m1_107_107# pfet_06v0_8u_8u_1nf
Xpfet_06v0_8u_8u_1nf_0[0|6] m1_107_107# m1_107_107# m1_107_107# m1_107_107# pfet_06v0_8u_8u_1nf
Xpfet_06v0_8u_8u_1nf_0[1|6] m2_61_3254# m2_61_3846# m1_107_107# m2_61_3498# pfet_06v0_8u_8u_1nf
Xpfet_06v0_8u_8u_1nf_0[2|6] m2_61_5230# m2_61_5822# m1_107_107# m2_61_5474# pfet_06v0_8u_8u_1nf
Xpfet_06v0_8u_8u_1nf_0[3|6] m1_107_107# m1_107_107# m1_107_107# m1_107_107# pfet_06v0_8u_8u_1nf
Xpfet_06v0_8u_8u_1nf_0[0|7] m1_107_107# m1_107_107# m1_107_107# m1_107_107# pfet_06v0_8u_8u_1nf
Xpfet_06v0_8u_8u_1nf_0[1|7] m2_61_3498# m2_61_3846# m1_107_107# m2_61_3010# pfet_06v0_8u_8u_1nf
Xpfet_06v0_8u_8u_1nf_0[2|7] m2_61_5474# m2_61_5822# m1_107_107# m2_61_4986# pfet_06v0_8u_8u_1nf
Xpfet_06v0_8u_8u_1nf_0[3|7] m1_107_107# m1_107_107# m1_107_107# m1_107_107# pfet_06v0_8u_8u_1nf
Xpfet_06v0_8u_8u_1nf_0[0|8] m1_107_107# m1_107_107# m1_107_107# m1_107_107# pfet_06v0_8u_8u_1nf
Xpfet_06v0_8u_8u_1nf_0[1|8] m2_61_2522# m2_61_3846# m1_107_107# m2_61_3498# pfet_06v0_8u_8u_1nf
Xpfet_06v0_8u_8u_1nf_0[2|8] m2_61_4498# m2_61_5822# m1_107_107# m2_61_5474# pfet_06v0_8u_8u_1nf
Xpfet_06v0_8u_8u_1nf_0[3|8] m1_107_107# m1_107_107# m1_107_107# m1_107_107# pfet_06v0_8u_8u_1nf
Xpfet_06v0_8u_8u_1nf_0[0|9] m1_107_107# m1_107_107# m1_107_107# m1_107_107# pfet_06v0_8u_8u_1nf
Xpfet_06v0_8u_8u_1nf_0[1|9] m2_61_3498# m2_61_3846# m1_107_107# m2_61_2766# pfet_06v0_8u_8u_1nf
Xpfet_06v0_8u_8u_1nf_0[2|9] m2_61_5474# m2_61_5822# m1_107_107# m2_61_5230# pfet_06v0_8u_8u_1nf
Xpfet_06v0_8u_8u_1nf_0[3|9] m1_107_107# m1_107_107# m1_107_107# m1_107_107# pfet_06v0_8u_8u_1nf
Xpfet_06v0_8u_8u_1nf_0[0|10] m1_107_107# m1_107_107# m1_107_107# m1_107_107# pfet_06v0_8u_8u_1nf
Xpfet_06v0_8u_8u_1nf_0[1|10] m2_61_2278# m2_61_3846# m1_107_107# m2_61_3498# pfet_06v0_8u_8u_1nf
Xpfet_06v0_8u_8u_1nf_0[2|10] m2_61_4254# m2_61_5822# m1_107_107# m2_61_5474# pfet_06v0_8u_8u_1nf
Xpfet_06v0_8u_8u_1nf_0[3|10] m1_107_107# m1_107_107# m1_107_107# m1_107_107# pfet_06v0_8u_8u_1nf
Xpfet_06v0_8u_8u_1nf_0[0|11] m1_107_107# m1_107_107# m1_107_107# m1_107_107# pfet_06v0_8u_8u_1nf
Xpfet_06v0_8u_8u_1nf_0[1|11] m1_107_107# m1_107_107# m1_107_107# m1_107_107# pfet_06v0_8u_8u_1nf
Xpfet_06v0_8u_8u_1nf_0[2|11] m1_107_107# m1_107_107# m1_107_107# m1_107_107# pfet_06v0_8u_8u_1nf
Xpfet_06v0_8u_8u_1nf_0[3|11] m1_107_107# m1_107_107# m1_107_107# m1_107_107# pfet_06v0_8u_8u_1nf
.ends

.subckt ppolyf_u_1k_6p0_1u_5u w_8_8# a_244_244# a_244_1366#
X0 a_244_1366# a_244_244# w_8_8# ppolyf_u_1k_6p0 r_width=1u r_length=5u
.ends

.subckt bgt__runits m2_4636_218# via__M1_M2_SQU_89/m1_0_0# m2_7948_2986# m2_5740_218#
+ m2_2428_218# m2_7948_1814# m2_5740_2986# m2_4084_2986# m2_3532_218# m2_5740_1390#
+ w_n40_n40# m2_4636_1390#
Xppolyf_u_1k_6p0_1u_5u_0[0|0] w_n40_n40# w_n40_n40# w_n40_n40# ppolyf_u_1k_6p0_1u_5u
Xppolyf_u_1k_6p0_1u_5u_0[1|0] w_n40_n40# w_n40_n40# w_n40_n40# ppolyf_u_1k_6p0_1u_5u
Xppolyf_u_1k_6p0_1u_5u_0[0|1] w_n40_n40# via__M1_M2_SQU_89/m1_0_0# m2_772_1390# ppolyf_u_1k_6p0_1u_5u
Xppolyf_u_1k_6p0_1u_5u_0[1|1] w_n40_n40# m2_772_1390# m2_772_2986# ppolyf_u_1k_6p0_1u_5u
Xppolyf_u_1k_6p0_1u_5u_0[0|2] w_n40_n40# m2_1324_218# m2_1324_1390# ppolyf_u_1k_6p0_1u_5u
Xppolyf_u_1k_6p0_1u_5u_0[1|2] w_n40_n40# m2_1324_1390# m2_772_2986# ppolyf_u_1k_6p0_1u_5u
Xppolyf_u_1k_6p0_1u_5u_0[0|3] w_n40_n40# m2_1324_218# m2_1876_1390# ppolyf_u_1k_6p0_1u_5u
Xppolyf_u_1k_6p0_1u_5u_0[1|3] w_n40_n40# m2_1876_1390# m2_1876_2986# ppolyf_u_1k_6p0_1u_5u
Xppolyf_u_1k_6p0_1u_5u_0[0|4] w_n40_n40# m2_2428_218# m2_2428_1390# ppolyf_u_1k_6p0_1u_5u
Xppolyf_u_1k_6p0_1u_5u_0[1|4] w_n40_n40# m2_2428_1390# m2_1876_2986# ppolyf_u_1k_6p0_1u_5u
Xppolyf_u_1k_6p0_1u_5u_0[0|5] w_n40_n40# m2_2428_218# m2_2980_1390# ppolyf_u_1k_6p0_1u_5u
Xppolyf_u_1k_6p0_1u_5u_0[1|5] w_n40_n40# m2_2980_1390# m2_2980_2986# ppolyf_u_1k_6p0_1u_5u
Xppolyf_u_1k_6p0_1u_5u_0[0|6] w_n40_n40# m2_3532_218# m2_3532_1390# ppolyf_u_1k_6p0_1u_5u
Xppolyf_u_1k_6p0_1u_5u_0[1|6] w_n40_n40# m2_3532_1390# m2_2980_2986# ppolyf_u_1k_6p0_1u_5u
Xppolyf_u_1k_6p0_1u_5u_0[0|7] w_n40_n40# m2_3532_218# m2_4084_1390# ppolyf_u_1k_6p0_1u_5u
Xppolyf_u_1k_6p0_1u_5u_0[1|7] w_n40_n40# m2_4084_1390# m2_4084_2986# ppolyf_u_1k_6p0_1u_5u
Xppolyf_u_1k_6p0_1u_5u_0[0|8] w_n40_n40# m2_4636_218# m2_4636_1390# ppolyf_u_1k_6p0_1u_5u
Xppolyf_u_1k_6p0_1u_5u_0[1|8] w_n40_n40# m2_4636_1390# m2_4084_2986# ppolyf_u_1k_6p0_1u_5u
Xppolyf_u_1k_6p0_1u_5u_0[0|9] w_n40_n40# m2_4636_218# m2_4636_1390# ppolyf_u_1k_6p0_1u_5u
Xppolyf_u_1k_6p0_1u_5u_0[1|9] w_n40_n40# w_n40_n40# w_n40_n40# ppolyf_u_1k_6p0_1u_5u
Xppolyf_u_1k_6p0_1u_5u_0[0|10] w_n40_n40# m2_5740_218# m2_5740_1390# ppolyf_u_1k_6p0_1u_5u
Xppolyf_u_1k_6p0_1u_5u_0[1|10] w_n40_n40# m2_5740_1390# m2_5740_2986# ppolyf_u_1k_6p0_1u_5u
Xppolyf_u_1k_6p0_1u_5u_0[0|11] w_n40_n40# m2_5740_218# m2_5740_1390# ppolyf_u_1k_6p0_1u_5u
Xppolyf_u_1k_6p0_1u_5u_0[1|11] w_n40_n40# m2_5740_1390# m2_5740_2986# ppolyf_u_1k_6p0_1u_5u
Xppolyf_u_1k_6p0_1u_5u_0[0|12] w_n40_n40# m2_5740_218# m2_5740_1390# ppolyf_u_1k_6p0_1u_5u
Xppolyf_u_1k_6p0_1u_5u_0[1|12] w_n40_n40# m2_5740_1390# m2_5740_2986# ppolyf_u_1k_6p0_1u_5u
Xppolyf_u_1k_6p0_1u_5u_0[0|13] w_n40_n40# m2_5740_218# m2_5740_1390# ppolyf_u_1k_6p0_1u_5u
Xppolyf_u_1k_6p0_1u_5u_0[1|13] w_n40_n40# m2_5740_1390# m2_5740_2986# ppolyf_u_1k_6p0_1u_5u
Xppolyf_u_1k_6p0_1u_5u_0[0|14] w_n40_n40# m2_5740_218# m2_5740_1390# ppolyf_u_1k_6p0_1u_5u
Xppolyf_u_1k_6p0_1u_5u_0[1|14] w_n40_n40# m2_7948_1814# m2_7948_2986# ppolyf_u_1k_6p0_1u_5u
Xppolyf_u_1k_6p0_1u_5u_0[0|15] w_n40_n40# m2_5740_218# m2_5740_1390# ppolyf_u_1k_6p0_1u_5u
Xppolyf_u_1k_6p0_1u_5u_0[1|15] w_n40_n40# m2_7948_1814# m2_7948_2986# ppolyf_u_1k_6p0_1u_5u
Xppolyf_u_1k_6p0_1u_5u_0[0|16] w_n40_n40# m2_5740_218# m2_5740_1390# ppolyf_u_1k_6p0_1u_5u
Xppolyf_u_1k_6p0_1u_5u_0[1|16] w_n40_n40# m2_7948_1814# m2_7948_2986# ppolyf_u_1k_6p0_1u_5u
Xppolyf_u_1k_6p0_1u_5u_0[0|17] w_n40_n40# m2_5740_218# m2_5740_1390# ppolyf_u_1k_6p0_1u_5u
Xppolyf_u_1k_6p0_1u_5u_0[1|17] w_n40_n40# m2_7948_1814# m2_7948_2986# ppolyf_u_1k_6p0_1u_5u
Xppolyf_u_1k_6p0_1u_5u_0[0|18] w_n40_n40# m2_7948_2986# m2_7948_1814# ppolyf_u_1k_6p0_1u_5u
Xppolyf_u_1k_6p0_1u_5u_0[1|18] w_n40_n40# m2_7948_1814# m2_7948_2986# ppolyf_u_1k_6p0_1u_5u
Xppolyf_u_1k_6p0_1u_5u_0[0|19] w_n40_n40# m2_7948_2986# m2_7948_1814# ppolyf_u_1k_6p0_1u_5u
Xppolyf_u_1k_6p0_1u_5u_0[1|19] w_n40_n40# m2_7948_1814# m2_7948_2986# ppolyf_u_1k_6p0_1u_5u
Xppolyf_u_1k_6p0_1u_5u_0[0|20] w_n40_n40# m2_7948_2986# m2_7948_1814# ppolyf_u_1k_6p0_1u_5u
Xppolyf_u_1k_6p0_1u_5u_0[1|20] w_n40_n40# m2_7948_1814# m2_7948_2986# ppolyf_u_1k_6p0_1u_5u
Xppolyf_u_1k_6p0_1u_5u_0[0|21] w_n40_n40# m2_7948_2986# m2_7948_1814# ppolyf_u_1k_6p0_1u_5u
Xppolyf_u_1k_6p0_1u_5u_0[1|21] w_n40_n40# m2_7948_1814# m2_7948_2986# ppolyf_u_1k_6p0_1u_5u
Xppolyf_u_1k_6p0_1u_5u_0[0|22] w_n40_n40# m2_7948_2986# m2_7948_1814# ppolyf_u_1k_6p0_1u_5u
Xppolyf_u_1k_6p0_1u_5u_0[1|22] w_n40_n40# m2_7948_1814# m2_7948_2986# ppolyf_u_1k_6p0_1u_5u
Xppolyf_u_1k_6p0_1u_5u_0[0|23] w_n40_n40# m2_7948_2986# m2_7948_1814# ppolyf_u_1k_6p0_1u_5u
Xppolyf_u_1k_6p0_1u_5u_0[1|23] w_n40_n40# m2_7948_1814# m2_7948_2986# ppolyf_u_1k_6p0_1u_5u
Xppolyf_u_1k_6p0_1u_5u_0[0|24] w_n40_n40# w_n40_n40# w_n40_n40# ppolyf_u_1k_6p0_1u_5u
Xppolyf_u_1k_6p0_1u_5u_0[1|24] w_n40_n40# w_n40_n40# w_n40_n40# ppolyf_u_1k_6p0_1u_5u
.ends

.subckt nfet_06v0_8u_1u_4nf a_784_272# a_584_180# a_480_272# a_1392_272# a_192_272#
+ a_280_180# a_1192_180# a_1088_272# a_48_48# a_888_180#
X0 a_1392_272# a_1192_180# a_1088_272# a_48_48# nfet_06v0 ad=3.52p pd=16.88u as=2.08p ps=8.52u w=8u l=1u
X1 a_1088_272# a_888_180# a_784_272# a_48_48# nfet_06v0 ad=2.08p pd=8.52u as=2.08p ps=8.52u w=8u l=1u
X2 a_784_272# a_584_180# a_480_272# a_48_48# nfet_06v0 ad=2.08p pd=8.52u as=2.08p ps=8.52u w=8u l=1u
X3 a_480_272# a_280_180# a_192_272# a_48_48# nfet_06v0 ad=2.08p pd=8.52u as=3.52p ps=16.88u w=8u l=1u
.ends

.subckt bgt__trimsw m2_282_6043# m2_282_4067# m2_6221_479# m2_205_1215# m2_6221_7143#
+ m2_205_479# m2_6298_6043# m2_205_2455# m2_205_3191# m2_6298_4067# m2_6221_1215#
+ m2_205_4431# m2_6298_115# m2_205_6407# m2_205_5167# m2_6221_4431# m2_6221_3191#
+ m2_282_2091# m2_6221_5167# m2_282_115# m2_6221_2455# m2_205_7143# m2_6298_2091#
+ m2_6221_6407# VSUBS
Xnfet_06v0_8u_1u_4nf_0[0|0] m2_205_479# m2_282_115# m2_205_1215# m2_205_479# m2_205_479#
+ m2_282_115# m2_282_115# m2_205_1215# VSUBS m2_282_115# nfet_06v0_8u_1u_4nf
Xnfet_06v0_8u_1u_4nf_0[1|0] m2_205_2455# m2_282_2091# m2_205_3191# m2_205_2455# m2_205_2455#
+ m2_282_2091# m2_282_2091# m2_205_3191# VSUBS m2_282_2091# nfet_06v0_8u_1u_4nf
Xnfet_06v0_8u_1u_4nf_0[2|0] m2_205_4431# m2_282_4067# m2_205_5167# m2_205_4431# m2_205_4431#
+ m2_282_4067# m2_282_4067# m2_205_5167# VSUBS m2_282_4067# nfet_06v0_8u_1u_4nf
Xnfet_06v0_8u_1u_4nf_0[3|0] m2_205_6407# m2_282_6043# m2_205_7143# m2_205_6407# m2_205_6407#
+ m2_282_6043# m2_282_6043# m2_205_7143# VSUBS m2_282_6043# nfet_06v0_8u_1u_4nf
Xnfet_06v0_8u_1u_4nf_0[0|1] m2_205_479# m2_282_115# m2_205_1215# m2_205_479# m2_205_479#
+ m2_282_115# m2_282_115# m2_205_1215# VSUBS m2_282_115# nfet_06v0_8u_1u_4nf
Xnfet_06v0_8u_1u_4nf_0[1|1] m2_205_2455# m2_282_2091# m2_205_3191# m2_205_2455# m2_205_2455#
+ m2_282_2091# m2_282_2091# m2_205_3191# VSUBS m2_282_2091# nfet_06v0_8u_1u_4nf
Xnfet_06v0_8u_1u_4nf_0[2|1] m2_205_4431# m2_282_4067# m2_205_5167# m2_205_4431# m2_205_4431#
+ m2_282_4067# m2_282_4067# m2_205_5167# VSUBS m2_282_4067# nfet_06v0_8u_1u_4nf
Xnfet_06v0_8u_1u_4nf_0[3|1] m2_205_6407# m2_282_6043# m2_205_7143# m2_205_6407# m2_205_6407#
+ m2_282_6043# m2_282_6043# m2_205_7143# VSUBS m2_282_6043# nfet_06v0_8u_1u_4nf
Xnfet_06v0_8u_1u_4nf_0[0|2] m2_205_479# m2_282_115# m2_205_1215# m2_205_479# m2_205_479#
+ m2_282_115# m2_282_115# m2_205_1215# VSUBS m2_282_115# nfet_06v0_8u_1u_4nf
Xnfet_06v0_8u_1u_4nf_0[1|2] m2_205_2455# m2_282_2091# m2_205_3191# m2_205_2455# m2_205_2455#
+ m2_282_2091# m2_282_2091# m2_205_3191# VSUBS m2_282_2091# nfet_06v0_8u_1u_4nf
Xnfet_06v0_8u_1u_4nf_0[2|2] m2_205_4431# m2_282_4067# m2_205_5167# m2_205_4431# m2_205_4431#
+ m2_282_4067# m2_282_4067# m2_205_5167# VSUBS m2_282_4067# nfet_06v0_8u_1u_4nf
Xnfet_06v0_8u_1u_4nf_0[3|2] m2_205_6407# m2_282_6043# m2_205_7143# m2_205_6407# m2_205_6407#
+ m2_282_6043# m2_282_6043# m2_205_7143# VSUBS m2_282_6043# nfet_06v0_8u_1u_4nf
Xnfet_06v0_8u_1u_4nf_0[0|3] m2_205_479# m2_282_115# m2_205_1215# m2_205_479# m2_205_479#
+ m2_282_115# m2_282_115# m2_205_1215# VSUBS m2_282_115# nfet_06v0_8u_1u_4nf
Xnfet_06v0_8u_1u_4nf_0[1|3] m2_205_2455# m2_282_2091# m2_205_3191# m2_205_2455# m2_205_2455#
+ m2_282_2091# m2_282_2091# m2_205_3191# VSUBS m2_282_2091# nfet_06v0_8u_1u_4nf
Xnfet_06v0_8u_1u_4nf_0[2|3] m2_205_4431# m2_282_4067# m2_205_5167# m2_205_4431# m2_205_4431#
+ m2_282_4067# m2_282_4067# m2_205_5167# VSUBS m2_282_4067# nfet_06v0_8u_1u_4nf
Xnfet_06v0_8u_1u_4nf_0[3|3] m2_205_6407# m2_282_6043# m2_205_7143# m2_205_6407# m2_205_6407#
+ m2_282_6043# m2_282_6043# m2_205_7143# VSUBS m2_282_6043# nfet_06v0_8u_1u_4nf
Xnfet_06v0_8u_1u_4nf_0[0|4] m2_6221_479# m2_6298_115# m2_6221_1215# m2_6221_479# m2_6221_479#
+ m2_6298_115# m2_6298_115# m2_6221_1215# VSUBS m2_6298_115# nfet_06v0_8u_1u_4nf
Xnfet_06v0_8u_1u_4nf_0[1|4] m2_6221_2455# m2_6298_2091# m2_6221_3191# m2_6221_2455#
+ m2_6221_2455# m2_6298_2091# m2_6298_2091# m2_6221_3191# VSUBS m2_6298_2091# nfet_06v0_8u_1u_4nf
Xnfet_06v0_8u_1u_4nf_0[2|4] m2_6221_4431# m2_6298_4067# m2_6221_5167# m2_6221_4431#
+ m2_6221_4431# m2_6298_4067# m2_6298_4067# m2_6221_5167# VSUBS m2_6298_4067# nfet_06v0_8u_1u_4nf
Xnfet_06v0_8u_1u_4nf_0[3|4] m2_6221_6407# m2_6298_6043# m2_6221_7143# m2_6221_6407#
+ m2_6221_6407# m2_6298_6043# m2_6298_6043# m2_6221_7143# VSUBS m2_6298_6043# nfet_06v0_8u_1u_4nf
Xnfet_06v0_8u_1u_4nf_0[0|5] m2_6221_479# m2_6298_115# m2_6221_1215# m2_6221_479# m2_6221_479#
+ m2_6298_115# m2_6298_115# m2_6221_1215# VSUBS m2_6298_115# nfet_06v0_8u_1u_4nf
Xnfet_06v0_8u_1u_4nf_0[1|5] m2_6221_2455# m2_6298_2091# m2_6221_3191# m2_6221_2455#
+ m2_6221_2455# m2_6298_2091# m2_6298_2091# m2_6221_3191# VSUBS m2_6298_2091# nfet_06v0_8u_1u_4nf
Xnfet_06v0_8u_1u_4nf_0[2|5] m2_6221_4431# m2_6298_4067# m2_6221_5167# m2_6221_4431#
+ m2_6221_4431# m2_6298_4067# m2_6298_4067# m2_6221_5167# VSUBS m2_6298_4067# nfet_06v0_8u_1u_4nf
Xnfet_06v0_8u_1u_4nf_0[3|5] m2_6221_6407# m2_6298_6043# m2_6221_7143# m2_6221_6407#
+ m2_6221_6407# m2_6298_6043# m2_6298_6043# m2_6221_7143# VSUBS m2_6298_6043# nfet_06v0_8u_1u_4nf
Xnfet_06v0_8u_1u_4nf_0[0|6] m2_6221_479# m2_6298_115# m2_6221_1215# m2_6221_479# m2_6221_479#
+ m2_6298_115# m2_6298_115# m2_6221_1215# VSUBS m2_6298_115# nfet_06v0_8u_1u_4nf
Xnfet_06v0_8u_1u_4nf_0[1|6] m2_6221_2455# m2_6298_2091# m2_6221_3191# m2_6221_2455#
+ m2_6221_2455# m2_6298_2091# m2_6298_2091# m2_6221_3191# VSUBS m2_6298_2091# nfet_06v0_8u_1u_4nf
Xnfet_06v0_8u_1u_4nf_0[2|6] m2_6221_4431# m2_6298_4067# m2_6221_5167# m2_6221_4431#
+ m2_6221_4431# m2_6298_4067# m2_6298_4067# m2_6221_5167# VSUBS m2_6298_4067# nfet_06v0_8u_1u_4nf
Xnfet_06v0_8u_1u_4nf_0[3|6] m2_6221_6407# m2_6298_6043# m2_6221_7143# m2_6221_6407#
+ m2_6221_6407# m2_6298_6043# m2_6298_6043# m2_6221_7143# VSUBS m2_6298_6043# nfet_06v0_8u_1u_4nf
Xnfet_06v0_8u_1u_4nf_0[0|7] m2_6221_479# m2_6298_115# m2_6221_1215# m2_6221_479# m2_6221_479#
+ m2_6298_115# m2_6298_115# m2_6221_1215# VSUBS m2_6298_115# nfet_06v0_8u_1u_4nf
Xnfet_06v0_8u_1u_4nf_0[1|7] m2_6221_2455# m2_6298_2091# m2_6221_3191# m2_6221_2455#
+ m2_6221_2455# m2_6298_2091# m2_6298_2091# m2_6221_3191# VSUBS m2_6298_2091# nfet_06v0_8u_1u_4nf
Xnfet_06v0_8u_1u_4nf_0[2|7] m2_6221_4431# m2_6298_4067# m2_6221_5167# m2_6221_4431#
+ m2_6221_4431# m2_6298_4067# m2_6298_4067# m2_6221_5167# VSUBS m2_6298_4067# nfet_06v0_8u_1u_4nf
Xnfet_06v0_8u_1u_4nf_0[3|7] m2_6221_6407# m2_6298_6043# m2_6221_7143# m2_6221_6407#
+ m2_6221_6407# m2_6298_6043# m2_6298_6043# m2_6221_7143# VSUBS m2_6298_6043# nfet_06v0_8u_1u_4nf
.ends

.subckt bg__trimres bgt__trimsw_0/m2_6298_6043# m3_12631_7391# bgt__trimsw_0/m2_6298_4067#
+ bgt__trimsw_0/m2_6298_115# bgt__trimsw_0/m2_282_115# bgt__trimsw_0/m2_282_2091#
+ bgt__runits_0/w_n40_n40# bgt__trimsw_0/m2_282_6043# bgt__trimsw_0/m2_6298_2091#
+ VSUBS bgt__trimsw_0/m2_282_4067# m3_788_8323#
Xbgt__runits_0 m3_5204_1339# m3_788_8323# m3_12631_7391# m3_6458_5291# m3_1213_5291#
+ m3_6458_5291# m3_5204_1339# m3_1213_1339# m3_1213_3315# m3_5756_3315# bgt__runits_0/w_n40_n40#
+ m3_1213_603# bgt__runits
Xbgt__trimsw_0 bgt__trimsw_0/m2_282_6043# bgt__trimsw_0/m2_282_4067# m3_1213_603#
+ m3_1213_1339# m3_12631_7391# m3_1213_603# bgt__trimsw_0/m2_6298_6043# m3_1213_1339#
+ m3_1213_3315# bgt__trimsw_0/m2_6298_4067# m3_5204_1339# m3_1213_3315# bgt__trimsw_0/m2_6298_115#
+ m3_1213_5291# m3_1213_5291# m3_5756_3315# m3_5756_3315# bgt__trimsw_0/m2_282_2091#
+ m3_6458_5291# bgt__trimsw_0/m2_282_115# m3_5204_1339# m3_788_8323# bgt__trimsw_0/m2_6298_2091#
+ m3_6458_5291# VSUBS bgt__trimsw
.ends

.subckt pnp_05p00x05p00 a_32_32# w_148_148# a_328_328#
X0 a_328_328# w_148_148# a_32_32# pnp_05p00x05p00
**devattr d=1000000,4000
.ends

.subckt bg__pnp_group m2_2088_2088# pnp_05p00x05p00_0[2|2]/a_328_328# VSUBS
Xpnp_05p00x05p00_0[0|0] VSUBS VSUBS VSUBS pnp_05p00x05p00
Xpnp_05p00x05p00_0[1|0] VSUBS VSUBS VSUBS pnp_05p00x05p00
Xpnp_05p00x05p00_0[2|0] VSUBS VSUBS VSUBS pnp_05p00x05p00
Xpnp_05p00x05p00_0[3|0] VSUBS VSUBS VSUBS pnp_05p00x05p00
Xpnp_05p00x05p00_0[4|0] VSUBS VSUBS VSUBS pnp_05p00x05p00
Xpnp_05p00x05p00_0[0|1] VSUBS VSUBS VSUBS pnp_05p00x05p00
Xpnp_05p00x05p00_0[1|1] VSUBS VSUBS m2_2088_2088# pnp_05p00x05p00
Xpnp_05p00x05p00_0[2|1] VSUBS VSUBS m2_2088_2088# pnp_05p00x05p00
Xpnp_05p00x05p00_0[3|1] VSUBS VSUBS m2_2088_2088# pnp_05p00x05p00
Xpnp_05p00x05p00_0[4|1] VSUBS VSUBS VSUBS pnp_05p00x05p00
Xpnp_05p00x05p00_0[0|2] VSUBS VSUBS VSUBS pnp_05p00x05p00
Xpnp_05p00x05p00_0[1|2] VSUBS VSUBS m2_2088_2088# pnp_05p00x05p00
Xpnp_05p00x05p00_0[2|2] VSUBS VSUBS pnp_05p00x05p00_0[2|2]/a_328_328# pnp_05p00x05p00
Xpnp_05p00x05p00_0[3|2] VSUBS VSUBS m2_2088_2088# pnp_05p00x05p00
Xpnp_05p00x05p00_0[4|2] VSUBS VSUBS VSUBS pnp_05p00x05p00
Xpnp_05p00x05p00_0[0|3] VSUBS VSUBS VSUBS pnp_05p00x05p00
Xpnp_05p00x05p00_0[1|3] VSUBS VSUBS m2_2088_2088# pnp_05p00x05p00
Xpnp_05p00x05p00_0[2|3] VSUBS VSUBS m2_2088_2088# pnp_05p00x05p00
Xpnp_05p00x05p00_0[3|3] VSUBS VSUBS m2_2088_2088# pnp_05p00x05p00
Xpnp_05p00x05p00_0[4|3] VSUBS VSUBS VSUBS pnp_05p00x05p00
Xpnp_05p00x05p00_0[0|4] VSUBS VSUBS VSUBS pnp_05p00x05p00
Xpnp_05p00x05p00_0[1|4] VSUBS VSUBS VSUBS pnp_05p00x05p00
Xpnp_05p00x05p00_0[2|4] VSUBS VSUBS VSUBS pnp_05p00x05p00
Xpnp_05p00x05p00_0[3|4] VSUBS VSUBS VSUBS pnp_05p00x05p00
Xpnp_05p00x05p00_0[4|4] VSUBS VSUBS VSUBS pnp_05p00x05p00
.ends

.subckt pfet_06v0_8u_4u_2nf a_1184_180# a_1080_272# a_192_272# a_280_180# w_16_16#
+ a_1984_272#
X0 a_1080_272# a_280_180# a_192_272# w_16_16# pfet_06v0 ad=2.08p pd=8.52u as=3.52p ps=16.88u w=8u l=4u
X1 a_1984_272# a_1184_180# a_1080_272# w_16_16# pfet_06v0 ad=3.52p pd=16.88u as=2.08p ps=8.52u w=8u l=4u
.ends

.subckt bga__md1_md2 m2_0_5324# m2_0_2924# m2_0_4476# m2_0_2500# m2_0_3783# m2_0_2065#
+ m2_0_5759# m2_0_4900# m2_0_3348# m1_107_107#
Xpfet_06v0_8u_4u_2nf_0[0|0] m1_107_107# m1_107_107# m1_107_107# m1_107_107# m1_107_107#
+ m1_107_107# pfet_06v0_8u_4u_2nf
Xpfet_06v0_8u_4u_2nf_0[1|0] m1_107_107# m1_107_107# m1_107_107# m1_107_107# m1_107_107#
+ m1_107_107# pfet_06v0_8u_4u_2nf
Xpfet_06v0_8u_4u_2nf_0[2|0] m1_107_107# m1_107_107# m1_107_107# m1_107_107# m1_107_107#
+ m1_107_107# pfet_06v0_8u_4u_2nf
Xpfet_06v0_8u_4u_2nf_0[3|0] m1_107_107# m1_107_107# m1_107_107# m1_107_107# m1_107_107#
+ m1_107_107# pfet_06v0_8u_4u_2nf
Xpfet_06v0_8u_4u_2nf_0[0|1] m1_107_107# m1_107_107# m1_107_107# m1_107_107# m1_107_107#
+ m1_107_107# pfet_06v0_8u_4u_2nf
Xpfet_06v0_8u_4u_2nf_0[1|1] m2_0_2065# m2_0_2924# m2_0_3348# m2_0_2065# m1_107_107#
+ m2_0_3348# pfet_06v0_8u_4u_2nf
Xpfet_06v0_8u_4u_2nf_0[2|1] m2_0_5759# m2_0_4900# m2_0_4476# m2_0_5759# m1_107_107#
+ m2_0_4476# pfet_06v0_8u_4u_2nf
Xpfet_06v0_8u_4u_2nf_0[3|1] m1_107_107# m1_107_107# m1_107_107# m1_107_107# m1_107_107#
+ m1_107_107# pfet_06v0_8u_4u_2nf
Xpfet_06v0_8u_4u_2nf_0[0|2] m1_107_107# m1_107_107# m1_107_107# m1_107_107# m1_107_107#
+ m1_107_107# pfet_06v0_8u_4u_2nf
Xpfet_06v0_8u_4u_2nf_0[1|2] m2_0_3783# m2_0_2500# m2_0_3348# m2_0_3783# m1_107_107#
+ m2_0_3348# pfet_06v0_8u_4u_2nf
Xpfet_06v0_8u_4u_2nf_0[2|2] m2_0_3783# m2_0_5324# m2_0_4476# m2_0_3783# m1_107_107#
+ m2_0_4476# pfet_06v0_8u_4u_2nf
Xpfet_06v0_8u_4u_2nf_0[3|2] m1_107_107# m1_107_107# m1_107_107# m1_107_107# m1_107_107#
+ m1_107_107# pfet_06v0_8u_4u_2nf
Xpfet_06v0_8u_4u_2nf_0[0|3] m1_107_107# m1_107_107# m1_107_107# m1_107_107# m1_107_107#
+ m1_107_107# pfet_06v0_8u_4u_2nf
Xpfet_06v0_8u_4u_2nf_0[1|3] m2_0_3783# m2_0_2500# m2_0_3348# m2_0_3783# m1_107_107#
+ m2_0_3348# pfet_06v0_8u_4u_2nf
Xpfet_06v0_8u_4u_2nf_0[2|3] m2_0_3783# m2_0_5324# m2_0_4476# m2_0_3783# m1_107_107#
+ m2_0_4476# pfet_06v0_8u_4u_2nf
Xpfet_06v0_8u_4u_2nf_0[3|3] m1_107_107# m1_107_107# m1_107_107# m1_107_107# m1_107_107#
+ m1_107_107# pfet_06v0_8u_4u_2nf
Xpfet_06v0_8u_4u_2nf_0[0|4] m1_107_107# m1_107_107# m1_107_107# m1_107_107# m1_107_107#
+ m1_107_107# pfet_06v0_8u_4u_2nf
Xpfet_06v0_8u_4u_2nf_0[1|4] m2_0_2065# m2_0_2924# m2_0_3348# m2_0_2065# m1_107_107#
+ m2_0_3348# pfet_06v0_8u_4u_2nf
Xpfet_06v0_8u_4u_2nf_0[2|4] m2_0_5759# m2_0_4900# m2_0_4476# m2_0_5759# m1_107_107#
+ m2_0_4476# pfet_06v0_8u_4u_2nf
Xpfet_06v0_8u_4u_2nf_0[3|4] m1_107_107# m1_107_107# m1_107_107# m1_107_107# m1_107_107#
+ m1_107_107# pfet_06v0_8u_4u_2nf
Xpfet_06v0_8u_4u_2nf_0[0|5] m1_107_107# m1_107_107# m1_107_107# m1_107_107# m1_107_107#
+ m1_107_107# pfet_06v0_8u_4u_2nf
Xpfet_06v0_8u_4u_2nf_0[1|5] m1_107_107# m1_107_107# m1_107_107# m1_107_107# m1_107_107#
+ m1_107_107# pfet_06v0_8u_4u_2nf
Xpfet_06v0_8u_4u_2nf_0[2|5] m1_107_107# m1_107_107# m1_107_107# m1_107_107# m1_107_107#
+ m1_107_107# pfet_06v0_8u_4u_2nf
Xpfet_06v0_8u_4u_2nf_0[3|5] m1_107_107# m1_107_107# m1_107_107# m1_107_107# m1_107_107#
+ m1_107_107# pfet_06v0_8u_4u_2nf
.ends

.subckt pfet_06v0_8u_2u_2nf a_680_272# a_1184_272# a_192_272# a_280_180# w_16_16#
+ a_784_180#
X0 a_680_272# a_280_180# a_192_272# w_16_16# pfet_06v0 ad=2.08p pd=8.52u as=3.52p ps=16.88u w=8u l=2u
X1 a_1184_272# a_784_180# a_680_272# w_16_16# pfet_06v0 ad=3.52p pd=16.88u as=2.08p ps=8.52u w=8u l=2u
.ends

.subckt bga__mc7_mc8 m2_61_1548# m2_61_3252# m2_61_948# m2_61_648# m2_61_2952# m2_61_2352#
+ m2_205_348#
Xpfet_06v0_8u_2u_2nf_0[0|0] m2_205_348# m2_61_948# m2_61_948# m2_61_1548# m2_205_348#
+ m2_61_1548# pfet_06v0_8u_2u_2nf
Xpfet_06v0_8u_2u_2nf_0[1|0] m2_205_348# m2_61_3252# m2_61_3252# m2_61_2352# m2_205_348#
+ m2_61_2352# pfet_06v0_8u_2u_2nf
Xpfet_06v0_8u_2u_2nf_0[0|1] m2_205_348# m2_61_648# m2_61_648# m2_61_1548# m2_205_348#
+ m2_61_1548# pfet_06v0_8u_2u_2nf
Xpfet_06v0_8u_2u_2nf_0[1|1] m2_205_348# m2_61_2952# m2_61_2952# m2_61_2352# m2_205_348#
+ m2_61_2352# pfet_06v0_8u_2u_2nf
Xpfet_06v0_8u_2u_2nf_0[0|2] m2_205_348# m2_205_348# m2_205_348# m2_205_348# m2_205_348#
+ m2_205_348# pfet_06v0_8u_2u_2nf
Xpfet_06v0_8u_2u_2nf_0[1|2] m2_205_348# m2_205_348# m2_205_348# m2_205_348# m2_205_348#
+ m2_205_348# pfet_06v0_8u_2u_2nf
.ends

.subckt nfet_06v0_8u_2u_2nf a_680_272# a_1184_272# a_192_272# a_280_180# a_784_180#
+ a_48_48#
X0 a_1184_272# a_784_180# a_680_272# a_48_48# nfet_06v0 ad=3.52p pd=16.88u as=2.08p ps=8.52u w=8u l=2u
X1 a_680_272# a_280_180# a_192_272# a_48_48# nfet_06v0 ad=2.08p pd=8.52u as=3.52p ps=16.88u w=8u l=2u
.ends

.subckt bga__mb5_mc1_mc2 m2_107_61# m2_61_3562# m2_61_3262# m2_61_658# m2_61_358#
+ VSUBS
Xnfet_06v0_8u_2u_2nf_0[0|0] m2_61_358# VSUBS VSUBS m2_107_61# m2_107_61# VSUBS nfet_06v0_8u_2u_2nf
Xnfet_06v0_8u_2u_2nf_0[1|0] m2_61_3562# VSUBS VSUBS m2_107_61# m2_107_61# VSUBS nfet_06v0_8u_2u_2nf
Xnfet_06v0_8u_2u_2nf_0[0|1] m2_61_658# VSUBS VSUBS m2_107_61# m2_107_61# VSUBS nfet_06v0_8u_2u_2nf
Xnfet_06v0_8u_2u_2nf_0[1|1] m2_61_3262# VSUBS VSUBS m2_107_61# m2_107_61# VSUBS nfet_06v0_8u_2u_2nf
Xnfet_06v0_8u_2u_2nf_0[0|2] m2_61_658# VSUBS VSUBS m2_107_61# m2_107_61# VSUBS nfet_06v0_8u_2u_2nf
Xnfet_06v0_8u_2u_2nf_0[1|2] m2_61_3262# VSUBS VSUBS m2_107_61# m2_107_61# VSUBS nfet_06v0_8u_2u_2nf
Xnfet_06v0_8u_2u_2nf_0[0|3] m2_107_61# VSUBS VSUBS m2_107_61# m2_107_61# VSUBS nfet_06v0_8u_2u_2nf
Xnfet_06v0_8u_2u_2nf_0[1|3] m2_107_61# VSUBS VSUBS m2_107_61# m2_107_61# VSUBS nfet_06v0_8u_2u_2nf
Xnfet_06v0_8u_2u_2nf_0[0|4] m2_61_358# VSUBS VSUBS m2_107_61# m2_107_61# VSUBS nfet_06v0_8u_2u_2nf
Xnfet_06v0_8u_2u_2nf_0[1|4] m2_61_3562# VSUBS VSUBS m2_107_61# m2_107_61# VSUBS nfet_06v0_8u_2u_2nf
Xnfet_06v0_8u_2u_2nf_0[0|5] m2_61_658# VSUBS VSUBS m2_107_61# m2_107_61# VSUBS nfet_06v0_8u_2u_2nf
Xnfet_06v0_8u_2u_2nf_0[1|5] m2_61_3562# VSUBS VSUBS m2_107_61# m2_107_61# VSUBS nfet_06v0_8u_2u_2nf
Xnfet_06v0_8u_2u_2nf_0[0|6] m2_61_658# VSUBS VSUBS m2_107_61# m2_107_61# VSUBS nfet_06v0_8u_2u_2nf
Xnfet_06v0_8u_2u_2nf_0[1|6] m2_61_3562# VSUBS VSUBS m2_107_61# m2_107_61# VSUBS nfet_06v0_8u_2u_2nf
Xnfet_06v0_8u_2u_2nf_0[0|7] m2_61_358# VSUBS VSUBS m2_107_61# m2_107_61# VSUBS nfet_06v0_8u_2u_2nf
Xnfet_06v0_8u_2u_2nf_0[1|7] m2_61_3562# VSUBS VSUBS m2_107_61# m2_107_61# VSUBS nfet_06v0_8u_2u_2nf
Xnfet_06v0_8u_2u_2nf_0[0|8] m2_107_61# VSUBS VSUBS m2_107_61# m2_107_61# VSUBS nfet_06v0_8u_2u_2nf
Xnfet_06v0_8u_2u_2nf_0[1|8] m2_107_61# VSUBS VSUBS m2_107_61# m2_107_61# VSUBS nfet_06v0_8u_2u_2nf
Xnfet_06v0_8u_2u_2nf_0[0|9] m2_61_658# VSUBS VSUBS m2_107_61# m2_107_61# VSUBS nfet_06v0_8u_2u_2nf
Xnfet_06v0_8u_2u_2nf_0[1|9] m2_61_3262# VSUBS VSUBS m2_107_61# m2_107_61# VSUBS nfet_06v0_8u_2u_2nf
Xnfet_06v0_8u_2u_2nf_0[0|10] m2_61_658# VSUBS VSUBS m2_107_61# m2_107_61# VSUBS nfet_06v0_8u_2u_2nf
Xnfet_06v0_8u_2u_2nf_0[1|10] m2_61_3262# VSUBS VSUBS m2_107_61# m2_107_61# VSUBS nfet_06v0_8u_2u_2nf
Xnfet_06v0_8u_2u_2nf_0[0|11] m2_61_358# VSUBS VSUBS m2_107_61# m2_107_61# VSUBS nfet_06v0_8u_2u_2nf
Xnfet_06v0_8u_2u_2nf_0[1|11] m2_61_3562# VSUBS VSUBS m2_107_61# m2_107_61# VSUBS nfet_06v0_8u_2u_2nf
Xnfet_06v0_8u_2u_2nf_0[0|12] VSUBS VSUBS VSUBS VSUBS VSUBS VSUBS nfet_06v0_8u_2u_2nf
Xnfet_06v0_8u_2u_2nf_0[1|12] VSUBS VSUBS VSUBS VSUBS VSUBS VSUBS nfet_06v0_8u_2u_2nf
.ends

.subckt bga__mb1_mb2_mt1 m2_61_858# m2_61_2862# m2_61_3362# m2_61_107# m2_61_358#
+ m2_61_2362#
Xpfet_06v0_8u_2u_2nf_0[0|0] m2_61_2362# m2_61_2362# m2_61_2362# m2_61_2362# m2_61_2362#
+ m2_61_2362# pfet_06v0_8u_2u_2nf
Xpfet_06v0_8u_2u_2nf_0[1|0] m2_61_2362# m2_61_2362# m2_61_2362# m2_61_2362# m2_61_2362#
+ m2_61_2362# pfet_06v0_8u_2u_2nf
Xpfet_06v0_8u_2u_2nf_0[0|1] m2_61_358# m2_61_2362# m2_61_2362# m2_61_107# m2_61_2362#
+ m2_61_107# pfet_06v0_8u_2u_2nf
Xpfet_06v0_8u_2u_2nf_0[1|1] m2_61_3362# m2_61_2362# m2_61_2362# m2_61_107# m2_61_2362#
+ m2_61_107# pfet_06v0_8u_2u_2nf
Xpfet_06v0_8u_2u_2nf_0[0|2] m2_61_858# m2_61_2362# m2_61_2362# m2_61_107# m2_61_2362#
+ m2_61_107# pfet_06v0_8u_2u_2nf
Xpfet_06v0_8u_2u_2nf_0[1|2] m2_61_2862# m2_61_2362# m2_61_2362# m2_61_107# m2_61_2362#
+ m2_61_107# pfet_06v0_8u_2u_2nf
Xpfet_06v0_8u_2u_2nf_0[0|3] m2_61_107# m2_61_2362# m2_61_2362# m2_61_107# m2_61_2362#
+ m2_61_107# pfet_06v0_8u_2u_2nf
Xpfet_06v0_8u_2u_2nf_0[1|3] m2_61_107# m2_61_2362# m2_61_2362# m2_61_107# m2_61_2362#
+ m2_61_107# pfet_06v0_8u_2u_2nf
Xpfet_06v0_8u_2u_2nf_0[0|4] m2_61_358# m2_61_2362# m2_61_2362# m2_61_107# m2_61_2362#
+ m2_61_107# pfet_06v0_8u_2u_2nf
Xpfet_06v0_8u_2u_2nf_0[1|4] m2_61_3362# m2_61_2362# m2_61_2362# m2_61_107# m2_61_2362#
+ m2_61_107# pfet_06v0_8u_2u_2nf
Xpfet_06v0_8u_2u_2nf_0[0|5] m2_61_358# m2_61_2362# m2_61_2362# m2_61_107# m2_61_2362#
+ m2_61_107# pfet_06v0_8u_2u_2nf
Xpfet_06v0_8u_2u_2nf_0[1|5] m2_61_3362# m2_61_2362# m2_61_2362# m2_61_107# m2_61_2362#
+ m2_61_107# pfet_06v0_8u_2u_2nf
Xpfet_06v0_8u_2u_2nf_0[0|6] m2_61_107# m2_61_2362# m2_61_2362# m2_61_107# m2_61_2362#
+ m2_61_107# pfet_06v0_8u_2u_2nf
Xpfet_06v0_8u_2u_2nf_0[1|6] m2_61_107# m2_61_2362# m2_61_2362# m2_61_107# m2_61_2362#
+ m2_61_107# pfet_06v0_8u_2u_2nf
Xpfet_06v0_8u_2u_2nf_0[0|7] m2_61_858# m2_61_2362# m2_61_2362# m2_61_107# m2_61_2362#
+ m2_61_107# pfet_06v0_8u_2u_2nf
Xpfet_06v0_8u_2u_2nf_0[1|7] m2_61_2862# m2_61_2362# m2_61_2362# m2_61_107# m2_61_2362#
+ m2_61_107# pfet_06v0_8u_2u_2nf
Xpfet_06v0_8u_2u_2nf_0[0|8] m2_61_358# m2_61_2362# m2_61_2362# m2_61_107# m2_61_2362#
+ m2_61_107# pfet_06v0_8u_2u_2nf
Xpfet_06v0_8u_2u_2nf_0[1|8] m2_61_3362# m2_61_2362# m2_61_2362# m2_61_107# m2_61_2362#
+ m2_61_107# pfet_06v0_8u_2u_2nf
Xpfet_06v0_8u_2u_2nf_0[0|9] m2_61_2362# m2_61_2362# m2_61_2362# m2_61_2362# m2_61_2362#
+ m2_61_2362# pfet_06v0_8u_2u_2nf
Xpfet_06v0_8u_2u_2nf_0[1|9] m2_61_2362# m2_61_2362# m2_61_2362# m2_61_2362# m2_61_2362#
+ m2_61_2362# pfet_06v0_8u_2u_2nf
.ends

.subckt bga__mb4_mc3_mc4 m2_61_3862# m2_61_1260# m2_61_61# m2_61_1858# m2_61_2658#
+ m2_61_3262# m2_61_3562# m2_61_958# m2_61_658# m2_61_358# m2_61_2960# VSUBS
Xnfet_06v0_8u_2u_2nf_0[0|0] VSUBS VSUBS VSUBS VSUBS VSUBS VSUBS nfet_06v0_8u_2u_2nf
Xnfet_06v0_8u_2u_2nf_0[1|0] VSUBS VSUBS VSUBS VSUBS VSUBS VSUBS nfet_06v0_8u_2u_2nf
Xnfet_06v0_8u_2u_2nf_0[0|1] m2_61_1260# m2_61_358# m2_61_358# m2_61_61# m2_61_61#
+ VSUBS nfet_06v0_8u_2u_2nf
Xnfet_06v0_8u_2u_2nf_0[1|1] m2_61_2658# m2_61_3562# m2_61_3562# m2_61_3862# m2_61_3862#
+ VSUBS nfet_06v0_8u_2u_2nf
Xnfet_06v0_8u_2u_2nf_0[0|2] m2_61_61# m2_61_1858# m2_61_1858# m2_61_61# m2_61_61#
+ VSUBS nfet_06v0_8u_2u_2nf
Xnfet_06v0_8u_2u_2nf_0[1|2] m2_61_3862# m2_61_1858# m2_61_1858# m2_61_3862# m2_61_3862#
+ VSUBS nfet_06v0_8u_2u_2nf
Xnfet_06v0_8u_2u_2nf_0[0|3] m2_61_658# m2_61_958# m2_61_958# m2_61_61# m2_61_61# VSUBS
+ nfet_06v0_8u_2u_2nf
Xnfet_06v0_8u_2u_2nf_0[1|3] m2_61_3262# m2_61_2960# m2_61_2960# m2_61_3862# m2_61_3862#
+ VSUBS nfet_06v0_8u_2u_2nf
Xnfet_06v0_8u_2u_2nf_0[0|4] m2_61_658# m2_61_958# m2_61_958# m2_61_61# m2_61_61# VSUBS
+ nfet_06v0_8u_2u_2nf
Xnfet_06v0_8u_2u_2nf_0[1|4] m2_61_3262# m2_61_2960# m2_61_2960# m2_61_3862# m2_61_3862#
+ VSUBS nfet_06v0_8u_2u_2nf
Xnfet_06v0_8u_2u_2nf_0[0|5] m2_61_61# m2_61_1858# m2_61_1858# m2_61_61# m2_61_61#
+ VSUBS nfet_06v0_8u_2u_2nf
Xnfet_06v0_8u_2u_2nf_0[1|5] m2_61_3862# m2_61_1858# m2_61_1858# m2_61_3862# m2_61_3862#
+ VSUBS nfet_06v0_8u_2u_2nf
Xnfet_06v0_8u_2u_2nf_0[0|6] m2_61_1260# m2_61_358# m2_61_358# m2_61_61# m2_61_61#
+ VSUBS nfet_06v0_8u_2u_2nf
Xnfet_06v0_8u_2u_2nf_0[1|6] m2_61_2658# m2_61_3562# m2_61_3562# m2_61_3862# m2_61_3862#
+ VSUBS nfet_06v0_8u_2u_2nf
.ends

.subckt bga__mb3_mc5_mc6 m2_61_1548# m2_61_3552# m2_61_1248# m2_61_3252# m2_61_948#
+ m2_61_348# m2_61_648# m2_61_171# m2_61_2952# m2_61_2352# m2_61_2652# m1_107_107#
Xpfet_06v0_8u_2u_2nf_0[0|0] m1_107_107# m1_107_107# m1_107_107# m1_107_107# m1_107_107#
+ m1_107_107# pfet_06v0_8u_2u_2nf
Xpfet_06v0_8u_2u_2nf_0[1|0] m1_107_107# m1_107_107# m1_107_107# m1_107_107# m1_107_107#
+ m1_107_107# pfet_06v0_8u_2u_2nf
Xpfet_06v0_8u_2u_2nf_0[0|1] m2_61_1548# m2_61_648# m2_61_648# m2_61_171# m1_107_107#
+ m2_61_171# pfet_06v0_8u_2u_2nf
Xpfet_06v0_8u_2u_2nf_0[1|1] m2_61_2352# m2_61_3252# m2_61_3252# m2_61_171# m1_107_107#
+ m2_61_171# pfet_06v0_8u_2u_2nf
Xpfet_06v0_8u_2u_2nf_0[0|2] m2_61_1248# m2_61_948# m2_61_948# m2_61_171# m1_107_107#
+ m2_61_171# pfet_06v0_8u_2u_2nf
Xpfet_06v0_8u_2u_2nf_0[1|2] m2_61_2652# m2_61_2952# m2_61_2952# m2_61_171# m1_107_107#
+ m2_61_171# pfet_06v0_8u_2u_2nf
Xpfet_06v0_8u_2u_2nf_0[0|3] m2_61_171# m2_61_348# m2_61_348# m2_61_171# m1_107_107#
+ m2_61_171# pfet_06v0_8u_2u_2nf
Xpfet_06v0_8u_2u_2nf_0[1|3] m2_61_171# m2_61_3552# m2_61_3552# m2_61_171# m1_107_107#
+ m2_61_171# pfet_06v0_8u_2u_2nf
Xpfet_06v0_8u_2u_2nf_0[0|4] m2_61_1248# m2_61_948# m2_61_948# m2_61_171# m1_107_107#
+ m2_61_171# pfet_06v0_8u_2u_2nf
Xpfet_06v0_8u_2u_2nf_0[1|4] m2_61_2652# m2_61_2952# m2_61_2952# m2_61_171# m1_107_107#
+ m2_61_171# pfet_06v0_8u_2u_2nf
Xpfet_06v0_8u_2u_2nf_0[0|5] m2_61_1548# m2_61_648# m2_61_648# m2_61_171# m1_107_107#
+ m2_61_171# pfet_06v0_8u_2u_2nf
Xpfet_06v0_8u_2u_2nf_0[1|5] m2_61_2352# m2_61_3252# m2_61_3252# m2_61_171# m1_107_107#
+ m2_61_171# pfet_06v0_8u_2u_2nf
Xpfet_06v0_8u_2u_2nf_0[0|6] m1_107_107# m1_107_107# m1_107_107# m1_107_107# m1_107_107#
+ m1_107_107# pfet_06v0_8u_2u_2nf
Xpfet_06v0_8u_2u_2nf_0[1|6] m1_107_107# m1_107_107# m1_107_107# m1_107_107# m1_107_107#
+ m1_107_107# pfet_06v0_8u_2u_2nf
.ends

.subckt bg__amplifier bga__md1_md2_0/m2_0_3783# m3_1765_7717# m3_21701_9748# w_16_5668#
+ m4_1904_6377# VSUBS
Xbga__md1_md2_0 m3_106_1350# m3_542_1650# m3_12435_8152# m3_106_1350# bga__md1_md2_0/m2_0_3783#
+ m3_1765_7717# m3_1765_7717# m3_542_1650# m3_12435_8152# w_16_5668# bga__md1_md2
Xbga__mc7_mc8_0 m4_943_5738# m3_21090_10300# m3_24820_10601# m3_21090_10300# m3_24820_10601#
+ m4_943_5738# w_16_5668# bga__mc7_mc8
Xbga__mb5_mc1_mc2_0 bga__mb5_mc1_mc2_0/m2_107_61# m3_106_1350# m3_542_1650# m3_542_1650#
+ m3_106_1350# VSUBS bga__mb5_mc1_mc2
Xbga__mb1_mb2_mt1_0 m4_1437_5297# m4_1437_5297# m3_12435_8152# m3_14069_5769# m3_12435_8152#
+ w_16_5668# bga__mb1_mb2_mt1
Xbga__mb4_mc3_mc4_0 m4_1437_5297# m4_1904_6377# m4_1437_5297# bga__mb5_mc1_mc2_0/m2_107_61#
+ m4_1904_6377# m3_542_1650# m3_106_1350# m4_943_5738# m3_542_1650# m3_106_1350# m4_943_5738#
+ VSUBS bga__mb4_mc3_mc4
Xbga__mb3_mc5_mc6_0 m4_943_5738# m3_14069_5769# m4_1904_6377# m3_21090_10300# m3_24820_10601#
+ m3_14069_5769# m3_21090_10300# m3_21701_9748# m3_24820_10601# m4_943_5738# m4_1904_6377#
+ w_16_5668# bga__mb3_mc5_mc6
.ends

.subckt bandgap_cm w_33026_14832# m3_29379_24840# m2_40640_7621# m2_40640_1693# m3_8898_22092#
+ m2_28106_0# w_604_604# m2_40640_3669# m2_27822_0# m4_0_14925# m3_23976_26628# m2_28674_0#
+ m2_28390_0# m2_40640_5645# VSUBS
Xbg__mb2_mb3_0 m3_32202_26212# VSUBS m3_31611_16588# m3_32202_26212# m3_31611_16588#
+ VSUBS VSUBS bg__mb2_mb3
Xbg__mi1_mi2_me1_me2_me3_me4_0 m3_29379_24840# m3_30666_27298# m3_1064_4976# m3_28816_28022#
+ m3_32202_26212# VSUBS m4_0_14925# bg__mi1_mi2_me1_me2_me3_me4
Xbg__ms1_ms2_ms3_ms4_c1_0 m3_1064_4976# m3_29379_24840# m3_30666_27298# m3_28816_28022#
+ m3_37414_19345# VSUBS bg__ms1_ms2_ms3_ms4_c1
Xbg__r1_r2_r3_ro_0 VSUBS m3_8898_22092# m4_16074_16606# m2_3378_16142# m3_9450_13888#
+ VSUBS m3_9450_13888# m3_37414_19345# m4_0_14925# bg__r1_r2_r3_ro
Xbg__m1_m2_mb1_mo1_mo2_0 m3_23976_26628# m3_1064_4976# m3_8898_22092# m3_8898_22092#
+ m3_37414_19345# m3_32202_26212# m4_0_14925# m3_23976_26628# m3_9450_13888# m3_37414_19345#
+ m3_1064_4976# m3_32202_26212# m4_0_14925# m3_9450_13888# m4_0_14925# bg__m1_m2_mb1_mo1_mo2
Xbg__trimres_0 m2_40640_7621# VSUBS m2_40640_5645# m2_40640_1693# m2_28674_0# m2_28390_0#
+ m4_0_14925# m2_27822_0# m2_40640_3669# VSUBS m2_28106_0# m2_3378_16142# bg__trimres
Xbg__pnp_group_0 m4_16074_16606# m3_37414_19345# VSUBS bg__pnp_group
Xbg__amplifier_0 m3_37414_19345# m3_9450_13888# m3_31611_16588# m4_0_14925# m3_1064_4976#
+ VSUBS bg__amplifier
.ends

.subckt pfet_06v0_8u_1u_2nf a_784_272# a_584_180# a_480_272# a_192_272# a_280_180#
+ w_16_16#
X0 a_480_272# a_280_180# a_192_272# w_16_16# pfet_06v0 ad=2.08p pd=8.52u as=3.52p ps=16.88u w=8u l=1u
X1 a_784_272# a_584_180# a_480_272# w_16_16# pfet_06v0 ad=3.52p pd=16.88u as=2.08p ps=8.52u w=8u l=1u
.ends

.subckt tba__xmb3_xmb4 m2_166_333# m2_0_1123#
Xpfet_06v0_8u_1u_2nf_0[0] m2_166_746# m2_166_746# m2_0_1123# m2_166_746# m2_166_746#
+ m2_0_1123# pfet_06v0_8u_1u_2nf
Xpfet_06v0_8u_1u_2nf_0[1] m2_166_333# m2_166_333# m2_166_746# m2_166_333# m2_166_333#
+ m2_0_1123# pfet_06v0_8u_1u_2nf
.ends

.subckt nfet_06v0_8u_1u_2nf a_784_272# a_584_180# a_480_272# a_192_272# a_280_180#
+ a_48_48#
X0 a_784_272# a_584_180# a_480_272# a_48_48# nfet_06v0 ad=3.52p pd=16.88u as=2.08p ps=8.52u w=8u l=1u
X1 a_480_272# a_280_180# a_192_272# a_48_48# nfet_06v0 ad=2.08p pd=8.52u as=3.52p ps=16.88u w=8u l=1u
.ends

.subckt tba__xmb1_xmb2_xm5_xm6 m2_0_3107# m2_0_3515# m2_0_765# m2_0_1812# m2_0_1213#
+ m2_0_2659# m2_0_109# VSUBS
Xnfet_06v0_8u_1u_2nf_0[0|0] m2_0_1213# m2_0_109# m2_0_1812# m2_0_1213# m2_0_109# VSUBS
+ nfet_06v0_8u_1u_2nf
Xnfet_06v0_8u_1u_2nf_0[1|0] m2_0_2659# m2_0_3515# m2_0_1812# m2_0_2659# m2_0_3515#
+ VSUBS nfet_06v0_8u_1u_2nf
Xnfet_06v0_8u_1u_2nf_0[0|1] m2_0_1213# m2_0_109# m2_0_1812# m2_0_1213# m2_0_109# VSUBS
+ nfet_06v0_8u_1u_2nf
Xnfet_06v0_8u_1u_2nf_0[1|1] m2_0_2659# m2_0_3515# m2_0_1812# m2_0_2659# m2_0_3515#
+ VSUBS nfet_06v0_8u_1u_2nf
Xnfet_06v0_8u_1u_2nf_0[0|2] m2_0_1213# m2_0_109# m2_0_1812# m2_0_1213# m2_0_109# VSUBS
+ nfet_06v0_8u_1u_2nf
Xnfet_06v0_8u_1u_2nf_0[1|2] m2_0_2659# m2_0_3515# m2_0_1812# m2_0_2659# m2_0_3515#
+ VSUBS nfet_06v0_8u_1u_2nf
Xnfet_06v0_8u_1u_2nf_0[0|3] m2_0_765# m2_0_109# m2_0_1812# m2_0_765# m2_0_109# VSUBS
+ nfet_06v0_8u_1u_2nf
Xnfet_06v0_8u_1u_2nf_0[1|3] m2_0_3107# m2_0_3515# m2_0_1812# m2_0_3107# m2_0_3515#
+ VSUBS nfet_06v0_8u_1u_2nf
Xnfet_06v0_8u_1u_2nf_0[0|4] m2_0_109# m2_0_109# m2_0_1812# m2_0_109# m2_0_109# VSUBS
+ nfet_06v0_8u_1u_2nf
Xnfet_06v0_8u_1u_2nf_0[1|4] m2_0_3515# m2_0_3515# m2_0_1812# m2_0_3515# m2_0_3515#
+ VSUBS nfet_06v0_8u_1u_2nf
Xnfet_06v0_8u_1u_2nf_0[0|5] m2_0_765# m2_0_109# m2_0_1812# m2_0_765# m2_0_109# VSUBS
+ nfet_06v0_8u_1u_2nf
Xnfet_06v0_8u_1u_2nf_0[1|5] m2_0_3107# m2_0_3515# m2_0_1812# m2_0_3107# m2_0_3515#
+ VSUBS nfet_06v0_8u_1u_2nf
Xnfet_06v0_8u_1u_2nf_0[0|6] m2_0_1213# m2_0_109# m2_0_1812# m2_0_1213# m2_0_109# VSUBS
+ nfet_06v0_8u_1u_2nf
Xnfet_06v0_8u_1u_2nf_0[1|6] m2_0_2659# m2_0_3515# m2_0_1812# m2_0_2659# m2_0_3515#
+ VSUBS nfet_06v0_8u_1u_2nf
Xnfet_06v0_8u_1u_2nf_0[0|7] m2_0_1213# m2_0_109# m2_0_1812# m2_0_1213# m2_0_109# VSUBS
+ nfet_06v0_8u_1u_2nf
Xnfet_06v0_8u_1u_2nf_0[1|7] m2_0_2659# m2_0_3515# m2_0_1812# m2_0_2659# m2_0_3515#
+ VSUBS nfet_06v0_8u_1u_2nf
Xnfet_06v0_8u_1u_2nf_0[0|8] m2_0_1213# m2_0_109# m2_0_1812# m2_0_1213# m2_0_109# VSUBS
+ nfet_06v0_8u_1u_2nf
Xnfet_06v0_8u_1u_2nf_0[1|8] m2_0_2659# m2_0_3515# m2_0_1812# m2_0_2659# m2_0_3515#
+ VSUBS nfet_06v0_8u_1u_2nf
.ends

.subckt tba__xm3_xm4 m2_0_355# m2_0_3765# m2_0_2331# m2_0_948# m2_0_1789#
Xpfet_06v0_8u_4u_2nf_0[0|0] m2_0_948# m2_0_948# m2_0_948# m2_0_948# m2_0_948# m2_0_948#
+ pfet_06v0_8u_4u_2nf
Xpfet_06v0_8u_4u_2nf_0[1|0] m2_0_948# m2_0_948# m2_0_948# m2_0_948# m2_0_948# m2_0_948#
+ pfet_06v0_8u_4u_2nf
Xpfet_06v0_8u_4u_2nf_0[0|1] m2_0_1789# m2_0_948# m2_0_1789# m2_0_1789# m2_0_948# m2_0_1789#
+ pfet_06v0_8u_4u_2nf
Xpfet_06v0_8u_4u_2nf_0[1|1] m2_0_3765# m2_0_948# m2_0_2331# m2_0_3765# m2_0_948# m2_0_2331#
+ pfet_06v0_8u_4u_2nf
Xpfet_06v0_8u_4u_2nf_0[0|2] m2_0_1789# m2_0_948# m2_0_355# m2_0_1789# m2_0_948# m2_0_355#
+ pfet_06v0_8u_4u_2nf
Xpfet_06v0_8u_4u_2nf_0[1|2] m2_0_3765# m2_0_948# m2_0_3765# m2_0_3765# m2_0_948# m2_0_3765#
+ pfet_06v0_8u_4u_2nf
Xpfet_06v0_8u_4u_2nf_0[0|3] m2_0_948# m2_0_948# m2_0_948# m2_0_948# m2_0_948# m2_0_948#
+ pfet_06v0_8u_4u_2nf
Xpfet_06v0_8u_4u_2nf_0[1|3] m2_0_948# m2_0_948# m2_0_948# m2_0_948# m2_0_948# m2_0_948#
+ pfet_06v0_8u_4u_2nf
.ends

.subckt cap_mim_30u_30u m4_120_120# m4_0_0#
X0 m4_120_120# m4_0_0# cap_mim_2f0_m4m5_noshield c_width=30u c_length=30u
.ends

.subckt tba__cc cap_mim_30u_30u_0/m4_120_120# cap_mim_30u_30u_0/m4_0_0#
Xcap_mim_30u_30u_0 cap_mim_30u_30u_0/m4_120_120# cap_mim_30u_30u_0/m4_0_0# cap_mim_30u_30u
.ends

.subckt tba__xm1_xm2 m2_0_65# m2_0_1372# m2_0_1831# m2_0_948# m2_0_524# VSUBS
Xnfet_06v0_8u_2u_2nf_0[0] VSUBS VSUBS VSUBS VSUBS VSUBS VSUBS nfet_06v0_8u_2u_2nf
Xnfet_06v0_8u_2u_2nf_0[1] m2_0_524# m2_0_948# m2_0_948# m2_0_1831# m2_0_1831# VSUBS
+ nfet_06v0_8u_2u_2nf
Xnfet_06v0_8u_2u_2nf_0[2] m2_0_524# m2_0_1372# m2_0_1372# m2_0_65# m2_0_65# VSUBS
+ nfet_06v0_8u_2u_2nf
Xnfet_06v0_8u_2u_2nf_0[3] m2_0_524# m2_0_948# m2_0_948# m2_0_1831# m2_0_1831# VSUBS
+ nfet_06v0_8u_2u_2nf
Xnfet_06v0_8u_2u_2nf_0[4] m2_0_524# m2_0_1372# m2_0_1372# m2_0_65# m2_0_65# VSUBS
+ nfet_06v0_8u_2u_2nf
Xnfet_06v0_8u_2u_2nf_0[5] VSUBS VSUBS VSUBS VSUBS VSUBS VSUBS nfet_06v0_8u_2u_2nf
.ends

.subckt ppolyf_u_1k_6p0_9p5_2u_4nf w_8_8# a_1204_2266# a_244_244# a_724_244# a_1204_244#
+ a_724_2266# a_1684_2266# a_1684_244# a_244_2266#
X0 a_244_2266# a_244_244# w_8_8# ppolyf_u_1k_6p0 r_width=2u r_length=9.5u
X1 a_724_2266# a_724_244# w_8_8# ppolyf_u_1k_6p0 r_width=2u r_length=9.5u
X2 a_1204_2266# a_1204_244# w_8_8# ppolyf_u_1k_6p0 r_width=2u r_length=9.5u
X3 a_1684_2266# a_1684_244# w_8_8# ppolyf_u_1k_6p0 r_width=2u r_length=9.5u
.ends

.subckt tba__xrcc w_n24_n24# m1_262_172# m1_1702_172#
Xppolyf_u_1k_6p0_9p5_2u_4nf_0 w_n24_n24# m1_1222_2345# m1_262_172# m1_742_273# m1_742_273#
+ m1_262_2345# m1_1222_2345# m1_1702_172# m1_262_2345# ppolyf_u_1k_6p0_9p5_2u_4nf
.ends

.subckt pfet_06v0_8u_1u_12nf a_3216_272# a_784_272# a_1696_272# a_2104_180# a_3016_180#
+ a_2000_272# a_584_180# a_2912_272# a_1496_180# a_480_272# a_3824_272# a_1800_180#
+ a_1392_272# a_2712_180# a_192_272# a_280_180# a_3624_180# a_1192_180# a_2608_272#
+ a_3520_272# a_1088_272# w_16_16# a_2408_180# a_3320_180# a_2304_272# a_888_180#
X0 a_480_272# a_280_180# a_192_272# w_16_16# pfet_06v0 ad=2.08p pd=8.52u as=3.52p ps=16.88u w=8u l=1u
X1 a_3216_272# a_3016_180# a_2912_272# w_16_16# pfet_06v0 ad=2.08p pd=8.52u as=2.08p ps=8.52u w=8u l=1u
X2 a_1696_272# a_1496_180# a_1392_272# w_16_16# pfet_06v0 ad=2.08p pd=8.52u as=2.08p ps=8.52u w=8u l=1u
X3 a_2000_272# a_1800_180# a_1696_272# w_16_16# pfet_06v0 ad=2.08p pd=8.52u as=2.08p ps=8.52u w=8u l=1u
X4 a_1392_272# a_1192_180# a_1088_272# w_16_16# pfet_06v0 ad=2.08p pd=8.52u as=2.08p ps=8.52u w=8u l=1u
X5 a_2912_272# a_2712_180# a_2608_272# w_16_16# pfet_06v0 ad=2.08p pd=8.52u as=2.08p ps=8.52u w=8u l=1u
X6 a_1088_272# a_888_180# a_784_272# w_16_16# pfet_06v0 ad=2.08p pd=8.52u as=2.08p ps=8.52u w=8u l=1u
X7 a_3824_272# a_3624_180# a_3520_272# w_16_16# pfet_06v0 ad=3.52p pd=16.88u as=2.08p ps=8.52u w=8u l=1u
X8 a_2608_272# a_2408_180# a_2304_272# w_16_16# pfet_06v0 ad=2.08p pd=8.52u as=2.08p ps=8.52u w=8u l=1u
X9 a_784_272# a_584_180# a_480_272# w_16_16# pfet_06v0 ad=2.08p pd=8.52u as=2.08p ps=8.52u w=8u l=1u
X10 a_3520_272# a_3320_180# a_3216_272# w_16_16# pfet_06v0 ad=2.08p pd=8.52u as=2.08p ps=8.52u w=8u l=1u
X11 a_2304_272# a_2104_180# a_2000_272# w_16_16# pfet_06v0 ad=2.08p pd=8.52u as=2.08p ps=8.52u w=8u l=1u
.ends

.subckt tba__xm7 m2_0_1123# m2_0_341# m2_0_1836#
Xpfet_06v0_8u_1u_12nf_0 m2_0_341# m2_0_341# m2_0_1123# m2_0_1836# m2_0_1836# m2_0_341#
+ m2_0_1836# m2_0_1123# m2_0_1836# m2_0_1123# m2_0_341# m2_0_1836# m2_0_341# m2_0_1836#
+ m2_0_341# m2_0_1836# m2_0_1836# m2_0_1836# m2_0_341# m2_0_1123# m2_0_1123# m2_0_1123#
+ m2_0_1836# m2_0_1836# m2_0_1123# m2_0_1836# pfet_06v0_8u_1u_12nf
.ends

.subckt tb_amplifier tba__xm1_xm2_0/m2_0_1831# tba__xm1_xm2_0/m2_0_65# m3_8055_11362#
+ m5_6914_8027# m4_0_0# VSUBS
Xtba__xmb3_xmb4_0 m3_5258_6144# m4_0_0# tba__xmb3_xmb4
Xtba__xmb1_xmb2_xm5_xm6_0 m3_2257_8993# m3_8055_11362# m3_5258_6144# VSUBS m5_6914_8027#
+ m5_6914_8027# m3_8055_11362# VSUBS tba__xmb1_xmb2_xm5_xm6
Xtba__xm3_xm4_0 m3_960_1720# m3_1600_3154# m3_960_1720# m4_0_0# m3_1600_3154# tba__xm3_xm4
Xtba__cc_0 m5_6914_8027# m5_8397_6034# tba__cc
Xtba__xm1_xm2_0 tba__xm1_xm2_0/m2_0_65# m3_1600_3154# tba__xm1_xm2_0/m2_0_1831# m3_960_1720#
+ m3_2257_8993# VSUBS tba__xm1_xm2
Xtba__xrcc_0 m4_0_0# m3_960_1720# m5_8397_6034# tba__xrcc
Xtba__xm7_0 m4_0_0# m5_6914_8027# m3_960_1720# tba__xm7
.ends

.subckt testbuffer m3_1230_9739# tb_amplifier_0/tba__xm1_xm2_0/m2_0_1831# w_604_604#
+ tb_amplifier_0/m3_8055_11362# m1_827_827# VSUBS
Xtb_amplifier_0 tb_amplifier_0/tba__xm1_xm2_0/m2_0_1831# m3_1230_9739# tb_amplifier_0/m3_8055_11362#
+ m3_1230_9739# m1_827_827# VSUBS tb_amplifier
.ends

.subckt lvl__m1_m2 nfet_06v0_8u_1u_2nf_0/a_584_180# nfet_06v0_8u_1u_2nf_0/a_480_272#
+ nfet_06v0_8u_1u_2nf_0/a_192_272# nfet_06v0_8u_1u_2nf_0/a_280_180# nfet_06v0_8u_1u_2nf_0/a_784_272#
+ VSUBS
Xnfet_06v0_8u_1u_2nf_0 nfet_06v0_8u_1u_2nf_0/a_784_272# nfet_06v0_8u_1u_2nf_0/a_584_180#
+ nfet_06v0_8u_1u_2nf_0/a_480_272# nfet_06v0_8u_1u_2nf_0/a_192_272# nfet_06v0_8u_1u_2nf_0/a_280_180#
+ VSUBS nfet_06v0_8u_1u_2nf
.ends

.subckt lvl__mi3_mi4 pfet_06v0_8u_1u_2nf_0/a_584_180# pfet_06v0_8u_1u_2nf_0/a_480_272#
+ pfet_06v0_8u_1u_2nf_0/a_192_272# pfet_06v0_8u_1u_2nf_0/a_280_180# pfet_06v0_8u_1u_2nf_0/a_784_272#
+ pfet_06v0_8u_1u_2nf_0/w_16_16#
Xpfet_06v0_8u_1u_2nf_0 pfet_06v0_8u_1u_2nf_0/a_784_272# pfet_06v0_8u_1u_2nf_0/a_584_180#
+ pfet_06v0_8u_1u_2nf_0/a_480_272# pfet_06v0_8u_1u_2nf_0/a_192_272# pfet_06v0_8u_1u_2nf_0/a_280_180#
+ pfet_06v0_8u_1u_2nf_0/w_16_16# pfet_06v0_8u_1u_2nf
.ends

.subckt pfet_06v0_2u_1u_2nf a_784_272# a_584_180# a_480_272# a_192_272# a_280_180#
+ w_16_16#
X0 a_480_272# a_280_180# a_192_272# w_16_16# pfet_06v0 ad=0.52p pd=2.52u as=0.88p ps=4.88u w=2u l=1u
X1 a_784_272# a_584_180# a_480_272# w_16_16# pfet_06v0 ad=0.88p pd=4.88u as=0.52p ps=2.52u w=2u l=1u
.ends

.subckt lvl__m3_m4 pfet_06v0_2u_1u_2nf_0/w_16_16# pfet_06v0_2u_1u_2nf_0/a_584_180#
+ pfet_06v0_2u_1u_2nf_0/a_480_272# pfet_06v0_2u_1u_2nf_0/a_192_272# pfet_06v0_2u_1u_2nf_0/a_280_180#
+ pfet_06v0_2u_1u_2nf_0/a_784_272#
Xpfet_06v0_2u_1u_2nf_0 pfet_06v0_2u_1u_2nf_0/a_784_272# pfet_06v0_2u_1u_2nf_0/a_584_180#
+ pfet_06v0_2u_1u_2nf_0/a_480_272# pfet_06v0_2u_1u_2nf_0/a_192_272# pfet_06v0_2u_1u_2nf_0/a_280_180#
+ pfet_06v0_2u_1u_2nf_0/w_16_16# pfet_06v0_2u_1u_2nf
.ends

.subckt nfet_06v0_4u_1u_2nf a_784_272# a_584_180# a_480_272# a_192_272# a_280_180#
+ a_48_48#
X0 a_784_272# a_584_180# a_480_272# a_48_48# nfet_06v0 ad=1.76p pd=8.88u as=1.04p ps=4.52u w=4u l=1u
X1 a_480_272# a_280_180# a_192_272# a_48_48# nfet_06v0 ad=1.04p pd=4.52u as=1.76p ps=8.88u w=4u l=1u
.ends

.subckt lvl__mi1_mi2 nfet_06v0_4u_1u_2nf_0/a_584_180# nfet_06v0_4u_1u_2nf_0/a_480_272#
+ nfet_06v0_4u_1u_2nf_0/a_192_272# nfet_06v0_4u_1u_2nf_0/a_280_180# nfet_06v0_4u_1u_2nf_0/a_784_272#
+ VSUBS
Xnfet_06v0_4u_1u_2nf_0 nfet_06v0_4u_1u_2nf_0/a_784_272# nfet_06v0_4u_1u_2nf_0/a_584_180#
+ nfet_06v0_4u_1u_2nf_0/a_480_272# nfet_06v0_4u_1u_2nf_0/a_192_272# nfet_06v0_4u_1u_2nf_0/a_280_180#
+ VSUBS nfet_06v0_4u_1u_2nf
.ends

.subckt levelshifter m2_0_3379# lvl__mi3_mi4_0/pfet_06v0_8u_1u_2nf_0/w_16_16# via__M1_M3_SQU_11/via__M2_M3_SQU_0/m2_0_0#
+ m3_188_1259# via__M1_M3_SQU_9/via__M2_M3_SQU_0/m2_0_0# lvl__m3_m4_0/pfet_06v0_2u_1u_2nf_0/w_16_16#
+ m2_470_574# VSUBS
Xlvl__m1_m2_0 m3_734_2558# m2_470_574# m3_188_1259# m3_250_2558# m3_578_1708# VSUBS
+ lvl__m1_m2
Xlvl__mi3_mi4_0 m3_250_2558# via__M1_M3_SQU_9/via__M2_M3_SQU_0/m2_0_0# m3_250_2558#
+ m2_0_3379# m3_734_2558# lvl__mi3_mi4_0/pfet_06v0_8u_1u_2nf_0/w_16_16# lvl__mi3_mi4
Xlvl__m3_m4_0 lvl__m3_m4_0/pfet_06v0_2u_1u_2nf_0/w_16_16# m3_188_1259# via__M1_M3_SQU_11/via__M2_M3_SQU_0/m2_0_0#
+ m3_188_1259# m3_578_1708# m3_578_1708# lvl__m3_m4
Xlvl__mi1_mi2_0 m3_250_2558# m2_470_574# m3_250_2558# m2_0_3379# m3_734_2558# VSUBS
+ lvl__mi1_mi2
.ends

.subckt spdt__mi3_mi4 pfet_06v0_8u_1u_2nf_0/a_584_180# pfet_06v0_8u_1u_2nf_0/a_480_272#
+ pfet_06v0_8u_1u_2nf_0/a_280_180# pfet_06v0_8u_1u_2nf_0/a_192_272# pfet_06v0_8u_1u_2nf_0/w_16_16#
+ pfet_06v0_8u_1u_2nf_0/a_784_272#
Xpfet_06v0_8u_1u_2nf_0 pfet_06v0_8u_1u_2nf_0/a_784_272# pfet_06v0_8u_1u_2nf_0/a_584_180#
+ pfet_06v0_8u_1u_2nf_0/a_480_272# pfet_06v0_8u_1u_2nf_0/a_192_272# pfet_06v0_8u_1u_2nf_0/a_280_180#
+ pfet_06v0_8u_1u_2nf_0/w_16_16# pfet_06v0_8u_1u_2nf
.ends

.subckt spdt__mi1_mi2 nfet_06v0_4u_1u_2nf_0/a_584_180# nfet_06v0_4u_1u_2nf_0/a_480_272#
+ nfet_06v0_4u_1u_2nf_0/a_280_180# nfet_06v0_4u_1u_2nf_0/a_192_272# nfet_06v0_4u_1u_2nf_0/a_784_272#
+ VSUBS
Xnfet_06v0_4u_1u_2nf_0 nfet_06v0_4u_1u_2nf_0/a_784_272# nfet_06v0_4u_1u_2nf_0/a_584_180#
+ nfet_06v0_4u_1u_2nf_0/a_480_272# nfet_06v0_4u_1u_2nf_0/a_192_272# nfet_06v0_4u_1u_2nf_0/a_280_180#
+ VSUBS nfet_06v0_4u_1u_2nf
.ends

.subckt spdt__m1_m3 nfet_06v0_8u_1u_4nf_0[1]/a_480_272# nfet_06v0_8u_1u_4nf_0[1]/a_1088_272#
+ nfet_06v0_8u_1u_4nf_0[0]/a_192_272# nfet_06v0_8u_1u_4nf_0[0]/a_280_180# nfet_06v0_8u_1u_4nf_0[0]/a_1192_180#
+ nfet_06v0_8u_1u_4nf_0[1]/a_280_180# nfet_06v0_8u_1u_4nf_0[1]/a_192_272# nfet_06v0_8u_1u_4nf_0[0]/a_1088_272#
+ nfet_06v0_8u_1u_4nf_0[0]/a_888_180# nfet_06v0_8u_1u_4nf_0[1]/a_888_180# nfet_06v0_8u_1u_4nf_0[0]/a_784_272#
+ nfet_06v0_8u_1u_4nf_0[1]/a_784_272# nfet_06v0_8u_1u_4nf_0[1]/a_1392_272# nfet_06v0_8u_1u_4nf_0[0]/a_584_180#
+ nfet_06v0_8u_1u_4nf_0[1]/a_584_180# VSUBS nfet_06v0_8u_1u_4nf_0[0]/a_1392_272# nfet_06v0_8u_1u_4nf_0[1]/a_1192_180#
+ nfet_06v0_8u_1u_4nf_0[0]/a_480_272#
Xnfet_06v0_8u_1u_4nf_0[0] nfet_06v0_8u_1u_4nf_0[0]/a_784_272# nfet_06v0_8u_1u_4nf_0[0]/a_584_180#
+ nfet_06v0_8u_1u_4nf_0[0]/a_480_272# nfet_06v0_8u_1u_4nf_0[0]/a_1392_272# nfet_06v0_8u_1u_4nf_0[0]/a_192_272#
+ nfet_06v0_8u_1u_4nf_0[0]/a_280_180# nfet_06v0_8u_1u_4nf_0[0]/a_1192_180# nfet_06v0_8u_1u_4nf_0[0]/a_1088_272#
+ VSUBS nfet_06v0_8u_1u_4nf_0[0]/a_888_180# nfet_06v0_8u_1u_4nf
Xnfet_06v0_8u_1u_4nf_0[1] nfet_06v0_8u_1u_4nf_0[1]/a_784_272# nfet_06v0_8u_1u_4nf_0[1]/a_584_180#
+ nfet_06v0_8u_1u_4nf_0[1]/a_480_272# nfet_06v0_8u_1u_4nf_0[1]/a_1392_272# nfet_06v0_8u_1u_4nf_0[1]/a_192_272#
+ nfet_06v0_8u_1u_4nf_0[1]/a_280_180# nfet_06v0_8u_1u_4nf_0[1]/a_1192_180# nfet_06v0_8u_1u_4nf_0[1]/a_1088_272#
+ VSUBS nfet_06v0_8u_1u_4nf_0[1]/a_888_180# nfet_06v0_8u_1u_4nf
.ends

.subckt pfet_06v0_8u_1u_8nf a_784_272# a_1696_272# a_2104_180# a_2000_272# a_584_180#
+ a_1496_180# a_480_272# a_1800_180# a_1392_272# a_192_272# a_280_180# a_1192_180#
+ a_2608_272# a_1088_272# w_16_16# a_2408_180# a_2304_272# a_888_180#
X0 a_480_272# a_280_180# a_192_272# w_16_16# pfet_06v0 ad=2.08p pd=8.52u as=3.52p ps=16.88u w=8u l=1u
X1 a_1696_272# a_1496_180# a_1392_272# w_16_16# pfet_06v0 ad=2.08p pd=8.52u as=2.08p ps=8.52u w=8u l=1u
X2 a_2000_272# a_1800_180# a_1696_272# w_16_16# pfet_06v0 ad=2.08p pd=8.52u as=2.08p ps=8.52u w=8u l=1u
X3 a_1392_272# a_1192_180# a_1088_272# w_16_16# pfet_06v0 ad=2.08p pd=8.52u as=2.08p ps=8.52u w=8u l=1u
X4 a_1088_272# a_888_180# a_784_272# w_16_16# pfet_06v0 ad=2.08p pd=8.52u as=2.08p ps=8.52u w=8u l=1u
X5 a_2608_272# a_2408_180# a_2304_272# w_16_16# pfet_06v0 ad=3.52p pd=16.88u as=2.08p ps=8.52u w=8u l=1u
X6 a_784_272# a_584_180# a_480_272# w_16_16# pfet_06v0 ad=2.08p pd=8.52u as=2.08p ps=8.52u w=8u l=1u
X7 a_2304_272# a_2104_180# a_2000_272# w_16_16# pfet_06v0 ad=2.08p pd=8.52u as=2.08p ps=8.52u w=8u l=1u
.ends

.subckt spdt__m2_m4 pfet_06v0_8u_1u_8nf_0[0]/a_2608_272# pfet_06v0_8u_1u_8nf_0[1]/a_2408_180#
+ pfet_06v0_8u_1u_8nf_0[0]/a_584_180# pfet_06v0_8u_1u_8nf_0[0]/a_1088_272# pfet_06v0_8u_1u_8nf_0[1]/a_2304_272#
+ pfet_06v0_8u_1u_8nf_0[1]/a_584_180# pfet_06v0_8u_1u_8nf_0[0]/a_2408_180# pfet_06v0_8u_1u_8nf_0[0]/a_480_272#
+ pfet_06v0_8u_1u_8nf_0[1]/a_1696_272# pfet_06v0_8u_1u_8nf_0[1]/a_2104_180# pfet_06v0_8u_1u_8nf_0[1]/a_480_272#
+ pfet_06v0_8u_1u_8nf_0[0]/a_2304_272# pfet_06v0_8u_1u_8nf_0[1]/a_2000_272# pfet_06v0_8u_1u_8nf_0[0]/a_192_272#
+ pfet_06v0_8u_1u_8nf_0[1]/a_1496_180# pfet_06v0_8u_1u_8nf_0[0]/a_280_180# pfet_06v0_8u_1u_8nf_0[1]/a_280_180#
+ pfet_06v0_8u_1u_8nf_0[0]/a_1696_272# pfet_06v0_8u_1u_8nf_0[1]/a_192_272# pfet_06v0_8u_1u_8nf_0[0]/a_2104_180#
+ pfet_06v0_8u_1u_8nf_0[1]/a_1800_180# pfet_06v0_8u_1u_8nf_0[1]/a_1392_272# pfet_06v0_8u_1u_8nf_0[0]/a_2000_272#
+ pfet_06v0_8u_1u_8nf_0[0]/a_1496_180# pfet_06v0_8u_1u_8nf_0[0]/a_1392_272# pfet_06v0_8u_1u_8nf_0[1]/a_1192_180#
+ pfet_06v0_8u_1u_8nf_0[0]/a_1800_180# pfet_06v0_8u_1u_8nf_0[1]/w_16_16# pfet_06v0_8u_1u_8nf_0[1]/a_2608_272#
+ pfet_06v0_8u_1u_8nf_0[1]/a_888_180# pfet_06v0_8u_1u_8nf_0[0]/a_888_180# pfet_06v0_8u_1u_8nf_0[1]/a_1088_272#
+ pfet_06v0_8u_1u_8nf_0[0]/a_784_272# pfet_06v0_8u_1u_8nf_0[0]/a_1192_180# pfet_06v0_8u_1u_8nf_0[1]/a_784_272#
Xpfet_06v0_8u_1u_8nf_0[0] pfet_06v0_8u_1u_8nf_0[0]/a_784_272# pfet_06v0_8u_1u_8nf_0[0]/a_1696_272#
+ pfet_06v0_8u_1u_8nf_0[0]/a_2104_180# pfet_06v0_8u_1u_8nf_0[0]/a_2000_272# pfet_06v0_8u_1u_8nf_0[0]/a_584_180#
+ pfet_06v0_8u_1u_8nf_0[0]/a_1496_180# pfet_06v0_8u_1u_8nf_0[0]/a_480_272# pfet_06v0_8u_1u_8nf_0[0]/a_1800_180#
+ pfet_06v0_8u_1u_8nf_0[0]/a_1392_272# pfet_06v0_8u_1u_8nf_0[0]/a_192_272# pfet_06v0_8u_1u_8nf_0[0]/a_280_180#
+ pfet_06v0_8u_1u_8nf_0[0]/a_1192_180# pfet_06v0_8u_1u_8nf_0[0]/a_2608_272# pfet_06v0_8u_1u_8nf_0[0]/a_1088_272#
+ pfet_06v0_8u_1u_8nf_0[1]/w_16_16# pfet_06v0_8u_1u_8nf_0[0]/a_2408_180# pfet_06v0_8u_1u_8nf_0[0]/a_2304_272#
+ pfet_06v0_8u_1u_8nf_0[0]/a_888_180# pfet_06v0_8u_1u_8nf
Xpfet_06v0_8u_1u_8nf_0[1] pfet_06v0_8u_1u_8nf_0[1]/a_784_272# pfet_06v0_8u_1u_8nf_0[1]/a_1696_272#
+ pfet_06v0_8u_1u_8nf_0[1]/a_2104_180# pfet_06v0_8u_1u_8nf_0[1]/a_2000_272# pfet_06v0_8u_1u_8nf_0[1]/a_584_180#
+ pfet_06v0_8u_1u_8nf_0[1]/a_1496_180# pfet_06v0_8u_1u_8nf_0[1]/a_480_272# pfet_06v0_8u_1u_8nf_0[1]/a_1800_180#
+ pfet_06v0_8u_1u_8nf_0[1]/a_1392_272# pfet_06v0_8u_1u_8nf_0[1]/a_192_272# pfet_06v0_8u_1u_8nf_0[1]/a_280_180#
+ pfet_06v0_8u_1u_8nf_0[1]/a_1192_180# pfet_06v0_8u_1u_8nf_0[1]/a_2608_272# pfet_06v0_8u_1u_8nf_0[1]/a_1088_272#
+ pfet_06v0_8u_1u_8nf_0[1]/w_16_16# pfet_06v0_8u_1u_8nf_0[1]/a_2408_180# pfet_06v0_8u_1u_8nf_0[1]/a_2304_272#
+ pfet_06v0_8u_1u_8nf_0[1]/a_888_180# pfet_06v0_8u_1u_8nf
.ends

.subckt spdt m3_2278_750# m3_4874_750# m1_0_2436# m3_4328_1458# m2_0_2262# VSUBS
Xspdt__mi3_mi4_0 m3_3254_177# m1_0_2436# m2_0_2262# m3_3254_177# m1_0_2436# m3_774_1553#
+ spdt__mi3_mi4
Xspdt__mi1_mi2_0 m3_3254_177# VSUBS m2_0_2262# m3_3254_177# m3_774_1553# VSUBS spdt__mi1_mi2
Xspdt__m1_m3_0 m3_4328_1458# m3_4328_1458# m3_2278_750# m3_3254_177# m3_3254_177#
+ m3_774_1553# m3_4874_750# m3_4328_1458# m3_3254_177# m3_774_1553# m3_2278_750# m3_4874_750#
+ m3_4874_750# m3_3254_177# m3_774_1553# VSUBS m3_2278_750# m3_774_1553# m3_4328_1458#
+ spdt__m1_m3
Xspdt__m2_m4_0 m3_2278_750# m3_3254_177# m3_774_1553# m3_4328_1458# m3_4328_1458#
+ m3_3254_177# m3_774_1553# m3_4328_1458# m3_4328_1458# m3_3254_177# m3_4328_1458#
+ m3_4328_1458# m3_4874_750# m3_2278_750# m3_3254_177# m3_774_1553# m3_3254_177# m3_4328_1458#
+ m3_4874_750# m3_774_1553# m3_3254_177# m3_4874_750# m3_2278_750# m3_774_1553# m3_2278_750#
+ m3_3254_177# m3_774_1553# m1_0_2436# m3_4874_750# m3_3254_177# m3_774_1553# m3_4328_1458#
+ m3_2278_750# m3_774_1553# m3_4874_750# spdt__m2_m4
.ends

.subckt spdt__group spdt_1/m3_4874_750# spdt_1/m3_4328_1458# w_604_604# spdt_0/m3_2278_750#
+ spdt_0/m3_4874_750# spdt_0/m2_0_2262# spdt_1/m2_0_2262# spdt_0/m3_4328_1458# m1_719_719#
+ VSUBS spdt_1/m3_2278_750#
Xspdt_0 spdt_0/m3_2278_750# spdt_0/m3_4874_750# m1_719_719# spdt_0/m3_4328_1458# spdt_0/m2_0_2262#
+ VSUBS spdt
Xspdt_1 spdt_1/m3_2278_750# spdt_1/m3_4874_750# m1_719_719# spdt_1/m3_4328_1458# spdt_1/m2_0_2262#
+ VSUBS spdt
.ends
